* O211AD4 : abstract conversion of sky130_fd_sc_hd__o211a_4
* 60 abstract devices (width -> parallel min-width fingers)
.subckt O211AD4 A1 A2 B1 C1 VGND VPWR X
XO211AD4B A1 A2 B1 C1 VGND VGND VPWR VPWR X O211AD4B
.ends O211AD4

.subckt O211AD4B A1 A2 B1 C1 VGND VNB VPB VPWR X
X0 a_79_21# B1 VPWR VPB abpmos
X1 a_79_21# B1 VPWR VPB abpmos
X2 a_79_21# B1 VPWR VPB abpmos
X3 a_557_47# C1 a_79_21# VNB abnmos
X4 a_557_47# C1 a_79_21# VNB abnmos
X5 a_474_47# A2 VGND VNB abnmos
X6 a_474_47# A2 VGND VNB abnmos
X7 a_950_297# A2 a_79_21# VPB abpmos
X8 a_950_297# A2 a_79_21# VPB abpmos
X9 a_950_297# A2 a_79_21# VPB abpmos
X10 X a_79_21# VGND VNB abnmos
X11 X a_79_21# VGND VNB abnmos
X12 a_79_21# C1 a_748_47# VNB abnmos
X13 a_79_21# C1 a_748_47# VNB abnmos
X14 a_748_47# B1 a_474_47# VNB abnmos
X15 a_748_47# B1 a_474_47# VNB abnmos
X16 X a_79_21# VPWR VPB abpmos
X17 X a_79_21# VPWR VPB abpmos
X18 X a_79_21# VPWR VPB abpmos
X19 a_474_47# A1 VGND VNB abnmos
X20 a_474_47# A1 VGND VNB abnmos
X21 a_474_47# A1 VGND VNB abnmos
X22 a_474_47# A1 VGND VNB abnmos
X23 a_950_297# A1 VPWR VPB abpmos
X24 a_950_297# A1 VPWR VPB abpmos
X25 a_950_297# A1 VPWR VPB abpmos
X26 X a_79_21# VPWR VPB abpmos
X27 X a_79_21# VPWR VPB abpmos
X28 X a_79_21# VPWR VPB abpmos
X29 a_79_21# B1 VPWR VPB abpmos
X30 a_79_21# B1 VPWR VPB abpmos
X31 a_79_21# B1 VPWR VPB abpmos
X32 X a_79_21# VPWR VPB abpmos
X33 X a_79_21# VPWR VPB abpmos
X34 X a_79_21# VPWR VPB abpmos
X35 X a_79_21# VGND VNB abnmos
X36 X a_79_21# VGND VNB abnmos
X37 a_474_47# A2 VGND VNB abnmos
X38 a_474_47# A2 VGND VNB abnmos
X39 a_79_21# C1 VPWR VPB abpmos
X40 a_79_21# C1 VPWR VPB abpmos
X41 a_79_21# C1 VPWR VPB abpmos
X42 a_79_21# C1 VPWR VPB abpmos
X43 a_79_21# C1 VPWR VPB abpmos
X44 a_79_21# C1 VPWR VPB abpmos
X45 X a_79_21# VGND VNB abnmos
X46 X a_79_21# VGND VNB abnmos
X47 X a_79_21# VGND VNB abnmos
X48 X a_79_21# VGND VNB abnmos
X49 X a_79_21# VPWR VPB abpmos
X50 X a_79_21# VPWR VPB abpmos
X51 X a_79_21# VPWR VPB abpmos
X52 a_1122_297# A1 VPWR VPB abpmos
X53 a_1122_297# A1 VPWR VPB abpmos
X54 a_1122_297# A1 VPWR VPB abpmos
X55 a_79_21# A2 a_1122_297# VPB abpmos
X56 a_79_21# A2 a_1122_297# VPB abpmos
X57 a_79_21# A2 a_1122_297# VPB abpmos
X58 a_474_47# B1 a_557_47# VNB abnmos
X59 a_474_47# B1 a_557_47# VNB abnmos
.ends O211AD4B
