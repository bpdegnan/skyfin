* LPFLOW_ISOBUFSRCD16 : abstract conversion of sky130_fd_sc_hd__lpflow_isobufsrc_16
* 180 abstract devices (width -> parallel min-width fingers)
.subckt LPFLOW_ISOBUFSRCD16 A SLEEP VGND VPWR X
XLPFLOW_ISOBUFSRCD16B A SLEEP VGND VGND VPWR VPWR X LPFLOW_ISOBUFSRCD16B
.ends LPFLOW_ISOBUFSRCD16

.subckt LPFLOW_ISOBUFSRCD16B A SLEEP VGND VNB VPB VPWR X
X0 X SLEEP a_505_297# VPB abpmos
X1 X SLEEP a_505_297# VPB abpmos
X2 X SLEEP a_505_297# VPB abpmos
X3 X a_143_297# VGND VNB abnmos
X4 X a_143_297# VGND VNB abnmos
X5 a_143_297# A VPWR VPB abpmos
X6 a_143_297# A VPWR VPB abpmos
X7 a_143_297# A VPWR VPB abpmos
X8 X SLEEP VGND VNB abnmos
X9 X SLEEP VGND VNB abnmos
X10 a_505_297# a_143_297# VPWR VPB abpmos
X11 a_505_297# a_143_297# VPWR VPB abpmos
X12 a_505_297# a_143_297# VPWR VPB abpmos
X13 X a_143_297# VGND VNB abnmos
X14 X a_143_297# VGND VNB abnmos
X15 X a_143_297# VGND VNB abnmos
X16 X a_143_297# VGND VNB abnmos
X17 a_505_297# a_143_297# VPWR VPB abpmos
X18 a_505_297# a_143_297# VPWR VPB abpmos
X19 a_505_297# a_143_297# VPWR VPB abpmos
X20 a_143_297# A VGND VNB abnmos
X21 a_143_297# A VGND VNB abnmos
X22 a_505_297# SLEEP X VPB abpmos
X23 a_505_297# SLEEP X VPB abpmos
X24 a_505_297# SLEEP X VPB abpmos
X25 X a_143_297# VGND VNB abnmos
X26 X a_143_297# VGND VNB abnmos
X27 a_505_297# a_143_297# VPWR VPB abpmos
X28 a_505_297# a_143_297# VPWR VPB abpmos
X29 a_505_297# a_143_297# VPWR VPB abpmos
X30 X SLEEP a_505_297# VPB abpmos
X31 X SLEEP a_505_297# VPB abpmos
X32 X SLEEP a_505_297# VPB abpmos
X33 a_505_297# a_143_297# VPWR VPB abpmos
X34 a_505_297# a_143_297# VPWR VPB abpmos
X35 a_505_297# a_143_297# VPWR VPB abpmos
X36 X SLEEP VGND VNB abnmos
X37 X SLEEP VGND VNB abnmos
X38 a_505_297# a_143_297# VPWR VPB abpmos
X39 a_505_297# a_143_297# VPWR VPB abpmos
X40 a_505_297# a_143_297# VPWR VPB abpmos
X41 a_143_297# A VGND VNB abnmos
X42 a_143_297# A VGND VNB abnmos
X43 X SLEEP VGND VNB abnmos
X44 X SLEEP VGND VNB abnmos
X45 a_505_297# a_143_297# VPWR VPB abpmos
X46 a_505_297# a_143_297# VPWR VPB abpmos
X47 a_505_297# a_143_297# VPWR VPB abpmos
X48 X a_143_297# VGND VNB abnmos
X49 X a_143_297# VGND VNB abnmos
X50 X SLEEP VGND VNB abnmos
X51 X SLEEP VGND VNB abnmos
X52 X SLEEP a_505_297# VPB abpmos
X53 X SLEEP a_505_297# VPB abpmos
X54 X SLEEP a_505_297# VPB abpmos
X55 a_505_297# SLEEP X VPB abpmos
X56 a_505_297# SLEEP X VPB abpmos
X57 a_505_297# SLEEP X VPB abpmos
X58 a_505_297# SLEEP X VPB abpmos
X59 a_505_297# SLEEP X VPB abpmos
X60 a_505_297# SLEEP X VPB abpmos
X61 X a_143_297# VGND VNB abnmos
X62 X a_143_297# VGND VNB abnmos
X63 a_143_297# A VGND VNB abnmos
X64 a_143_297# A VGND VNB abnmos
X65 X a_143_297# VGND VNB abnmos
X66 X a_143_297# VGND VNB abnmos
X67 X SLEEP VGND VNB abnmos
X68 X SLEEP VGND VNB abnmos
X69 X SLEEP a_505_297# VPB abpmos
X70 X SLEEP a_505_297# VPB abpmos
X71 X SLEEP a_505_297# VPB abpmos
X72 a_143_297# A VPWR VPB abpmos
X73 a_143_297# A VPWR VPB abpmos
X74 a_143_297# A VPWR VPB abpmos
X75 a_143_297# A VPWR VPB abpmos
X76 a_143_297# A VPWR VPB abpmos
X77 a_143_297# A VPWR VPB abpmos
X78 a_505_297# a_143_297# VPWR VPB abpmos
X79 a_505_297# a_143_297# VPWR VPB abpmos
X80 a_505_297# a_143_297# VPWR VPB abpmos
X81 X SLEEP a_505_297# VPB abpmos
X82 X SLEEP a_505_297# VPB abpmos
X83 X SLEEP a_505_297# VPB abpmos
X84 X a_143_297# VGND VNB abnmos
X85 X a_143_297# VGND VNB abnmos
X86 X SLEEP a_505_297# VPB abpmos
X87 X SLEEP a_505_297# VPB abpmos
X88 X SLEEP a_505_297# VPB abpmos
X89 a_505_297# SLEEP X VPB abpmos
X90 a_505_297# SLEEP X VPB abpmos
X91 a_505_297# SLEEP X VPB abpmos
X92 X SLEEP VGND VNB abnmos
X93 X SLEEP VGND VNB abnmos
X94 X SLEEP VGND VNB abnmos
X95 X SLEEP VGND VNB abnmos
X96 a_143_297# A VPWR VPB abpmos
X97 a_143_297# A VPWR VPB abpmos
X98 a_143_297# A VPWR VPB abpmos
X99 a_505_297# a_143_297# VPWR VPB abpmos
X100 a_505_297# a_143_297# VPWR VPB abpmos
X101 a_505_297# a_143_297# VPWR VPB abpmos
X102 a_505_297# SLEEP X VPB abpmos
X103 a_505_297# SLEEP X VPB abpmos
X104 a_505_297# SLEEP X VPB abpmos
X105 X a_143_297# VGND VNB abnmos
X106 X a_143_297# VGND VNB abnmos
X107 a_505_297# a_143_297# VPWR VPB abpmos
X108 a_505_297# a_143_297# VPWR VPB abpmos
X109 a_505_297# a_143_297# VPWR VPB abpmos
X110 X SLEEP VGND VNB abnmos
X111 X SLEEP VGND VNB abnmos
X112 a_505_297# a_143_297# VPWR VPB abpmos
X113 a_505_297# a_143_297# VPWR VPB abpmos
X114 a_505_297# a_143_297# VPWR VPB abpmos
X115 X a_143_297# VGND VNB abnmos
X116 X a_143_297# VGND VNB abnmos
X117 a_505_297# a_143_297# VPWR VPB abpmos
X118 a_505_297# a_143_297# VPWR VPB abpmos
X119 a_505_297# a_143_297# VPWR VPB abpmos
X120 a_505_297# a_143_297# VPWR VPB abpmos
X121 a_505_297# a_143_297# VPWR VPB abpmos
X122 a_505_297# a_143_297# VPWR VPB abpmos
X123 X a_143_297# VGND VNB abnmos
X124 X a_143_297# VGND VNB abnmos
X125 X SLEEP VGND VNB abnmos
X126 X SLEEP VGND VNB abnmos
X127 a_505_297# a_143_297# VPWR VPB abpmos
X128 a_505_297# a_143_297# VPWR VPB abpmos
X129 a_505_297# a_143_297# VPWR VPB abpmos
X130 a_143_297# A VGND VNB abnmos
X131 a_143_297# A VGND VNB abnmos
X132 X a_143_297# VGND VNB abnmos
X133 X a_143_297# VGND VNB abnmos
X134 X SLEEP VGND VNB abnmos
X135 X SLEEP VGND VNB abnmos
X136 X SLEEP a_505_297# VPB abpmos
X137 X SLEEP a_505_297# VPB abpmos
X138 X SLEEP a_505_297# VPB abpmos
X139 X a_143_297# VGND VNB abnmos
X140 X a_143_297# VGND VNB abnmos
X141 X a_143_297# VGND VNB abnmos
X142 X a_143_297# VGND VNB abnmos
X143 a_505_297# a_143_297# VPWR VPB abpmos
X144 a_505_297# a_143_297# VPWR VPB abpmos
X145 a_505_297# a_143_297# VPWR VPB abpmos
X146 a_505_297# a_143_297# VPWR VPB abpmos
X147 a_505_297# a_143_297# VPWR VPB abpmos
X148 a_505_297# a_143_297# VPWR VPB abpmos
X149 a_505_297# SLEEP X VPB abpmos
X150 a_505_297# SLEEP X VPB abpmos
X151 a_505_297# SLEEP X VPB abpmos
X152 X a_143_297# VGND VNB abnmos
X153 X a_143_297# VGND VNB abnmos
X154 X SLEEP VGND VNB abnmos
X155 X SLEEP VGND VNB abnmos
X156 a_505_297# SLEEP X VPB abpmos
X157 a_505_297# SLEEP X VPB abpmos
X158 a_505_297# SLEEP X VPB abpmos
X159 X SLEEP VGND VNB abnmos
X160 X SLEEP VGND VNB abnmos
X161 X SLEEP VGND VNB abnmos
X162 X SLEEP VGND VNB abnmos
X163 a_505_297# SLEEP X VPB abpmos
X164 a_505_297# SLEEP X VPB abpmos
X165 a_505_297# SLEEP X VPB abpmos
X166 X SLEEP VGND VNB abnmos
X167 X SLEEP VGND VNB abnmos
X168 X a_143_297# VGND VNB abnmos
X169 X a_143_297# VGND VNB abnmos
X170 X SLEEP VGND VNB abnmos
X171 X SLEEP VGND VNB abnmos
X172 a_505_297# a_143_297# VPWR VPB abpmos
X173 a_505_297# a_143_297# VPWR VPB abpmos
X174 a_505_297# a_143_297# VPWR VPB abpmos
X175 X SLEEP a_505_297# VPB abpmos
X176 X SLEEP a_505_297# VPB abpmos
X177 X SLEEP a_505_297# VPB abpmos
X178 X SLEEP VGND VNB abnmos
X179 X SLEEP VGND VNB abnmos
.ends LPFLOW_ISOBUFSRCD16B
