* OR2BD1 : abstract conversion of sky130_fd_sc_hd__or2b_1
* 11 abstract devices (width -> parallel min-width fingers)
.subckt OR2BD1 A B_N VGND VPWR X
XOR2BD1B A B_N VGND VGND VPWR VPWR X OR2BD1B
.ends OR2BD1

.subckt OR2BD1B A B_N VGND VNB VPB VPWR X
X0 a_219_297# A VGND VNB abnmos
X1 a_27_53# B_N VGND VNB abnmos
X2 a_219_297# a_27_53# VGND VNB abnmos
X3 X a_219_297# VGND VNB abnmos
X4 X a_219_297# VGND VNB abnmos
X5 a_219_297# a_27_53# a_301_297# VPB abpmos
X6 a_301_297# A VPWR VPB abpmos
X7 a_27_53# B_N VPWR VPB abpmos
X8 X a_219_297# VPWR VPB abpmos
X9 X a_219_297# VPWR VPB abpmos
X10 X a_219_297# VPWR VPB abpmos
.ends OR2BD1B
