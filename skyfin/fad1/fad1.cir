* FAD1 : abstract conversion of sky130_fd_sc_hd__fa_1
* 34 abstract devices (width -> parallel min-width fingers)
.subckt FAD1 A B CIN VGND VPWR COUT SUM
XFAD1B A B CIN VGND VGND VPWR VPWR COUT SUM FAD1B
.ends FAD1

.subckt FAD1B A B CIN VGND VNB VPB VPWR COUT SUM
X0 a_208_47# A VGND VNB abnmos
X1 a_382_47# B VGND VNB abnmos
X2 a_1163_413# A VPWR VPB abpmos
X3 a_208_413# B a_76_199# VPB abpmos
X4 a_382_413# A VPWR VPB abpmos
X5 a_738_413# A VPWR VPB abpmos
X6 a_76_199# CIN a_382_413# VPB abpmos
X7 a_738_413# CIN VPWR VPB abpmos
X8 a_995_47# CIN a_1091_413# VPB abpmos
X9 a_382_413# B VPWR VPB abpmos
X10 a_1091_413# B a_1163_413# VPB abpmos
X11 a_738_47# A VGND VNB abnmos
X12 a_382_47# A VGND VNB abnmos
X13 a_738_47# B VGND VNB abnmos
X14 SUM a_995_47# VPWR VPB abpmos
X15 SUM a_995_47# VPWR VPB abpmos
X16 SUM a_995_47# VPWR VPB abpmos
X17 a_738_47# CIN VGND VNB abnmos
X18 a_738_47# a_76_199# a_995_47# VNB abnmos
X19 a_76_199# CIN a_382_47# VNB abnmos
X20 a_1091_47# B a_1163_47# VNB abnmos
X21 a_738_413# a_76_199# a_995_47# VPB abpmos
X22 SUM a_995_47# VGND VNB abnmos
X23 SUM a_995_47# VGND VNB abnmos
X24 a_738_413# B VPWR VPB abpmos
X25 a_1163_47# A VGND VNB abnmos
X26 a_208_413# A VPWR VPB abpmos
X27 COUT a_76_199# VGND VNB abnmos
X28 COUT a_76_199# VGND VNB abnmos
X29 COUT a_76_199# VPWR VPB abpmos
X30 COUT a_76_199# VPWR VPB abpmos
X31 COUT a_76_199# VPWR VPB abpmos
X32 a_208_47# B a_76_199# VNB abnmos
X33 a_995_47# CIN a_1091_47# VNB abnmos
.ends FAD1B
