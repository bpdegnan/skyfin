* A21OID2 : abstract conversion of sky130_fd_sc_hd__a21oi_2
* 30 abstract devices (width -> parallel min-width fingers)
.subckt A21OID2 A1 A2 B1 VGND VPWR Y
XA21OID2B A1 A2 B1 VGND VGND VPWR VPWR Y A21OID2B
.ends A21OID2

.subckt A21OID2B A1 A2 B1 VGND VNB VPB VPWR Y
X0 a_114_47# A2 VGND VNB abnmos
X1 a_114_47# A2 VGND VNB abnmos
X2 a_27_297# A1 VPWR VPB abpmos
X3 a_27_297# A1 VPWR VPB abpmos
X4 a_27_297# A1 VPWR VPB abpmos
X5 a_27_297# A2 VPWR VPB abpmos
X6 a_27_297# A2 VPWR VPB abpmos
X7 a_27_297# A2 VPWR VPB abpmos
X8 a_27_297# A2 VPWR VPB abpmos
X9 a_27_297# A2 VPWR VPB abpmos
X10 a_27_297# A2 VPWR VPB abpmos
X11 Y B1 a_27_297# VPB abpmos
X12 Y B1 a_27_297# VPB abpmos
X13 Y B1 a_27_297# VPB abpmos
X14 Y B1 VGND VNB abnmos
X15 Y B1 VGND VNB abnmos
X16 a_27_297# A1 VPWR VPB abpmos
X17 a_27_297# A1 VPWR VPB abpmos
X18 a_27_297# A1 VPWR VPB abpmos
X19 a_27_297# B1 Y VPB abpmos
X20 a_27_297# B1 Y VPB abpmos
X21 a_27_297# B1 Y VPB abpmos
X22 Y B1 VGND VNB abnmos
X23 Y B1 VGND VNB abnmos
X24 a_285_47# A2 VGND VNB abnmos
X25 a_285_47# A2 VGND VNB abnmos
X26 a_114_47# A1 Y VNB abnmos
X27 a_114_47# A1 Y VNB abnmos
X28 Y A1 a_285_47# VNB abnmos
X29 Y A1 a_285_47# VNB abnmos
.ends A21OID2B
