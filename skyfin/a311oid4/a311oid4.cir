* A311OID4 : abstract conversion of sky130_fd_sc_hd__a311oi_4
* 100 abstract devices (width -> parallel min-width fingers)
.subckt A311OID4 A1 A2 A3 B1 C1 VGND VPWR Y
XA311OID4B A1 A2 A3 B1 C1 VGND VGND VPWR VPWR Y A311OID4B
.ends A311OID4

.subckt A311OID4B A1 A2 A3 B1 C1 VGND VNB VPB VPWR Y
X0 a_109_297# A1 VPWR VPB abpmos
X1 a_109_297# A1 VPWR VPB abpmos
X2 a_109_297# A1 VPWR VPB abpmos
X3 a_109_297# B1 a_1139_297# VPB abpmos
X4 a_109_297# B1 a_1139_297# VPB abpmos
X5 a_109_297# B1 a_1139_297# VPB abpmos
X6 Y A1 a_445_47# VNB abnmos
X7 Y A1 a_445_47# VNB abnmos
X8 a_27_47# A2 a_445_47# VNB abnmos
X9 a_27_47# A2 a_445_47# VNB abnmos
X10 Y B1 VGND VNB abnmos
X11 Y B1 VGND VNB abnmos
X12 a_27_47# A2 a_445_47# VNB abnmos
X13 a_27_47# A2 a_445_47# VNB abnmos
X14 a_1139_297# B1 a_109_297# VPB abpmos
X15 a_1139_297# B1 a_109_297# VPB abpmos
X16 a_1139_297# B1 a_109_297# VPB abpmos
X17 Y A1 a_445_47# VNB abnmos
X18 Y A1 a_445_47# VNB abnmos
X19 Y C1 VGND VNB abnmos
X20 Y C1 VGND VNB abnmos
X21 a_109_297# A1 VPWR VPB abpmos
X22 a_109_297# A1 VPWR VPB abpmos
X23 a_109_297# A1 VPWR VPB abpmos
X24 a_109_297# A2 VPWR VPB abpmos
X25 a_109_297# A2 VPWR VPB abpmos
X26 a_109_297# A2 VPWR VPB abpmos
X27 a_1139_297# C1 Y VPB abpmos
X28 a_1139_297# C1 Y VPB abpmos
X29 a_1139_297# C1 Y VPB abpmos
X30 a_109_297# A2 VPWR VPB abpmos
X31 a_109_297# A2 VPWR VPB abpmos
X32 a_109_297# A2 VPWR VPB abpmos
X33 a_27_47# A3 VGND VNB abnmos
X34 a_27_47# A3 VGND VNB abnmos
X35 a_109_297# A1 VPWR VPB abpmos
X36 a_109_297# A1 VPWR VPB abpmos
X37 a_109_297# A1 VPWR VPB abpmos
X38 Y C1 a_1139_297# VPB abpmos
X39 Y C1 a_1139_297# VPB abpmos
X40 Y C1 a_1139_297# VPB abpmos
X41 a_109_297# A2 VPWR VPB abpmos
X42 a_109_297# A2 VPWR VPB abpmos
X43 a_109_297# A2 VPWR VPB abpmos
X44 Y C1 a_1139_297# VPB abpmos
X45 Y C1 a_1139_297# VPB abpmos
X46 Y C1 a_1139_297# VPB abpmos
X47 a_109_297# A1 VPWR VPB abpmos
X48 a_109_297# A1 VPWR VPB abpmos
X49 a_109_297# A1 VPWR VPB abpmos
X50 a_445_47# A2 a_27_47# VNB abnmos
X51 a_445_47# A2 a_27_47# VNB abnmos
X52 Y B1 VGND VNB abnmos
X53 Y B1 VGND VNB abnmos
X54 a_1139_297# C1 Y VPB abpmos
X55 a_1139_297# C1 Y VPB abpmos
X56 a_1139_297# C1 Y VPB abpmos
X57 Y C1 VGND VNB abnmos
X58 Y C1 VGND VNB abnmos
X59 a_27_47# A3 VGND VNB abnmos
X60 a_27_47# A3 VGND VNB abnmos
X61 a_27_47# A3 VGND VNB abnmos
X62 a_27_47# A3 VGND VNB abnmos
X63 a_109_297# A3 VPWR VPB abpmos
X64 a_109_297# A3 VPWR VPB abpmos
X65 a_109_297# A3 VPWR VPB abpmos
X66 a_27_47# A3 VGND VNB abnmos
X67 a_27_47# A3 VGND VNB abnmos
X68 Y B1 VGND VNB abnmos
X69 Y B1 VGND VNB abnmos
X70 a_109_297# A2 VPWR VPB abpmos
X71 a_109_297# A2 VPWR VPB abpmos
X72 a_109_297# A2 VPWR VPB abpmos
X73 a_109_297# A3 VPWR VPB abpmos
X74 a_109_297# A3 VPWR VPB abpmos
X75 a_109_297# A3 VPWR VPB abpmos
X76 a_1139_297# B1 a_109_297# VPB abpmos
X77 a_1139_297# B1 a_109_297# VPB abpmos
X78 a_1139_297# B1 a_109_297# VPB abpmos
X79 Y C1 VGND VNB abnmos
X80 Y C1 VGND VNB abnmos
X81 a_109_297# A3 VPWR VPB abpmos
X82 a_109_297# A3 VPWR VPB abpmos
X83 a_109_297# A3 VPWR VPB abpmos
X84 a_445_47# A1 Y VNB abnmos
X85 a_445_47# A1 Y VNB abnmos
X86 a_445_47# A2 a_27_47# VNB abnmos
X87 a_445_47# A2 a_27_47# VNB abnmos
X88 Y B1 VGND VNB abnmos
X89 Y B1 VGND VNB abnmos
X90 a_109_297# A3 VPWR VPB abpmos
X91 a_109_297# A3 VPWR VPB abpmos
X92 a_109_297# A3 VPWR VPB abpmos
X93 a_109_297# B1 a_1139_297# VPB abpmos
X94 a_109_297# B1 a_1139_297# VPB abpmos
X95 a_109_297# B1 a_1139_297# VPB abpmos
X96 a_445_47# A1 Y VNB abnmos
X97 a_445_47# A1 Y VNB abnmos
X98 Y C1 VGND VNB abnmos
X99 Y C1 VGND VNB abnmos
.ends A311OID4B
