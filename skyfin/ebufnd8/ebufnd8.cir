* EBUFND8 : abstract conversion of sky130_fd_sc_hd__ebufn_8
* 95 abstract devices (width -> parallel min-width fingers)
.subckt EBUFND8 A TE_B VGND VPWR Z
XEBUFND8B A TE_B VGND VGND VPWR VPWR Z EBUFND8B
.ends EBUFND8

.subckt EBUFND8B A TE_B VGND VNB VPB VPWR Z
X0 a_407_309# a_116_47# Z VPB abpmos
X1 a_407_309# a_116_47# Z VPB abpmos
X2 a_407_309# a_116_47# Z VPB abpmos
X3 a_407_309# TE_B VPWR VPB abpmos
X4 a_407_309# TE_B VPWR VPB abpmos
X5 a_407_309# TE_B VPWR VPB abpmos
X6 a_455_47# a_116_47# Z VNB abnmos
X7 a_455_47# a_116_47# Z VNB abnmos
X8 a_455_47# a_116_47# Z VNB abnmos
X9 a_455_47# a_116_47# Z VNB abnmos
X10 a_407_309# TE_B VPWR VPB abpmos
X11 a_407_309# TE_B VPWR VPB abpmos
X12 a_407_309# TE_B VPWR VPB abpmos
X13 a_407_309# TE_B VPWR VPB abpmos
X14 a_407_309# TE_B VPWR VPB abpmos
X15 a_407_309# TE_B VPWR VPB abpmos
X16 Z a_116_47# a_407_309# VPB abpmos
X17 Z a_116_47# a_407_309# VPB abpmos
X18 Z a_116_47# a_407_309# VPB abpmos
X19 Z a_116_47# a_407_309# VPB abpmos
X20 Z a_116_47# a_407_309# VPB abpmos
X21 Z a_116_47# a_407_309# VPB abpmos
X22 a_455_47# a_301_47# VGND VNB abnmos
X23 a_455_47# a_301_47# VGND VNB abnmos
X24 Z a_116_47# a_455_47# VNB abnmos
X25 Z a_116_47# a_455_47# VNB abnmos
X26 a_455_47# a_301_47# VGND VNB abnmos
X27 a_455_47# a_301_47# VGND VNB abnmos
X28 a_455_47# a_301_47# VGND VNB abnmos
X29 a_455_47# a_301_47# VGND VNB abnmos
X30 a_407_309# TE_B VPWR VPB abpmos
X31 a_407_309# TE_B VPWR VPB abpmos
X32 a_407_309# TE_B VPWR VPB abpmos
X33 a_455_47# a_301_47# VGND VNB abnmos
X34 a_455_47# a_301_47# VGND VNB abnmos
X35 a_116_47# A VGND VNB abnmos
X36 a_116_47# A VGND VNB abnmos
X37 a_407_309# TE_B VPWR VPB abpmos
X38 a_407_309# TE_B VPWR VPB abpmos
X39 a_407_309# TE_B VPWR VPB abpmos
X40 a_455_47# a_301_47# VGND VNB abnmos
X41 a_455_47# a_301_47# VGND VNB abnmos
X42 a_116_47# A VPWR VPB abpmos
X43 a_116_47# A VPWR VPB abpmos
X44 a_116_47# A VPWR VPB abpmos
X45 a_407_309# TE_B VPWR VPB abpmos
X46 a_407_309# TE_B VPWR VPB abpmos
X47 a_407_309# TE_B VPWR VPB abpmos
X48 a_116_47# A VGND VNB abnmos
X49 a_116_47# A VGND VNB abnmos
X50 a_116_47# A VPWR VPB abpmos
X51 a_116_47# A VPWR VPB abpmos
X52 a_116_47# A VPWR VPB abpmos
X53 a_455_47# a_116_47# Z VNB abnmos
X54 a_455_47# a_116_47# Z VNB abnmos
X55 Z a_116_47# a_407_309# VPB abpmos
X56 Z a_116_47# a_407_309# VPB abpmos
X57 Z a_116_47# a_407_309# VPB abpmos
X58 a_455_47# a_301_47# VGND VNB abnmos
X59 a_455_47# a_301_47# VGND VNB abnmos
X60 Z a_116_47# a_455_47# VNB abnmos
X61 Z a_116_47# a_455_47# VNB abnmos
X62 a_407_309# a_116_47# Z VPB abpmos
X63 a_407_309# a_116_47# Z VPB abpmos
X64 a_407_309# a_116_47# Z VPB abpmos
X65 Z a_116_47# a_455_47# VNB abnmos
X66 Z a_116_47# a_455_47# VNB abnmos
X67 a_301_47# TE_B VPWR VPB abpmos
X68 a_301_47# TE_B VPWR VPB abpmos
X69 a_301_47# TE_B VPWR VPB abpmos
X70 a_301_47# TE_B VGND VNB abnmos
X71 a_301_47# TE_B VGND VNB abnmos
X72 a_455_47# a_301_47# VGND VNB abnmos
X73 a_455_47# a_301_47# VGND VNB abnmos
X74 a_455_47# a_116_47# Z VNB abnmos
X75 a_455_47# a_116_47# Z VNB abnmos
X76 a_407_309# TE_B VPWR VPB abpmos
X77 a_407_309# TE_B VPWR VPB abpmos
X78 a_407_309# TE_B VPWR VPB abpmos
X79 Z a_116_47# a_407_309# VPB abpmos
X80 Z a_116_47# a_407_309# VPB abpmos
X81 Z a_116_47# a_407_309# VPB abpmos
X82 a_455_47# a_301_47# VGND VNB abnmos
X83 a_455_47# a_301_47# VGND VNB abnmos
X84 a_407_309# TE_B VPWR VPB abpmos
X85 a_407_309# TE_B VPWR VPB abpmos
X86 a_407_309# TE_B VPWR VPB abpmos
X87 a_407_309# a_116_47# Z VPB abpmos
X88 a_407_309# a_116_47# Z VPB abpmos
X89 a_407_309# a_116_47# Z VPB abpmos
X90 Z a_116_47# a_455_47# VNB abnmos
X91 Z a_116_47# a_455_47# VNB abnmos
X92 a_407_309# a_116_47# Z VPB abpmos
X93 a_407_309# a_116_47# Z VPB abpmos
X94 a_407_309# a_116_47# Z VPB abpmos
.ends EBUFND8B
