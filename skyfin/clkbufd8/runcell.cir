* auto-generated runcell for CLKBUFD8
.lib "$SPICE_LIB/sky130.lib.spice" tt
.include "$SPICE_DEVICES/devices.cir"
.include "clkbufd8.cir"

.param pvdd=1.8V
VVPWR VDD 0 {pvdd}
V_GND VGND 0 0

V_A A 0 PWL( 0ns 0 10ns 0 10.1ns {pvdd} 20ns {pvdd} )

X1 A VGND VDD X CLKBUFD8
CL_X X VGND 0.1f

.control
tran 0.05n 20n
wrdata result.raw v(A) v(X)
.endc
.end
