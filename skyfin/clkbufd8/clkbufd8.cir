* CLKBUFD8 : abstract conversion of sky130_fd_sc_hd__clkbuf_8
* 40 abstract devices (width -> parallel min-width fingers)
.subckt CLKBUFD8 A VGND VPWR X
XCLKBUFD8B A VGND VGND VPWR VPWR X CLKBUFD8B
.ends CLKBUFD8

.subckt CLKBUFD8B A VGND VNB VPB VPWR X
X0 X a_110_47# VGND VNB abnmos
X1 a_110_47# A VPWR VPB abpmos
X2 a_110_47# A VPWR VPB abpmos
X3 a_110_47# A VPWR VPB abpmos
X4 X a_110_47# VGND VNB abnmos
X5 a_110_47# A VPWR VPB abpmos
X6 a_110_47# A VPWR VPB abpmos
X7 a_110_47# A VPWR VPB abpmos
X8 X a_110_47# VGND VNB abnmos
X9 a_110_47# A VGND VNB abnmos
X10 X a_110_47# VGND VNB abnmos
X11 X a_110_47# VPWR VPB abpmos
X12 X a_110_47# VPWR VPB abpmos
X13 X a_110_47# VPWR VPB abpmos
X14 X a_110_47# VPWR VPB abpmos
X15 X a_110_47# VPWR VPB abpmos
X16 X a_110_47# VPWR VPB abpmos
X17 X a_110_47# VPWR VPB abpmos
X18 X a_110_47# VPWR VPB abpmos
X19 X a_110_47# VPWR VPB abpmos
X20 X a_110_47# VGND VNB abnmos
X21 X a_110_47# VGND VNB abnmos
X22 X a_110_47# VPWR VPB abpmos
X23 X a_110_47# VPWR VPB abpmos
X24 X a_110_47# VPWR VPB abpmos
X25 X a_110_47# VPWR VPB abpmos
X26 X a_110_47# VPWR VPB abpmos
X27 X a_110_47# VPWR VPB abpmos
X28 X a_110_47# VPWR VPB abpmos
X29 X a_110_47# VPWR VPB abpmos
X30 X a_110_47# VPWR VPB abpmos
X31 X a_110_47# VPWR VPB abpmos
X32 X a_110_47# VPWR VPB abpmos
X33 X a_110_47# VPWR VPB abpmos
X34 X a_110_47# VPWR VPB abpmos
X35 X a_110_47# VPWR VPB abpmos
X36 X a_110_47# VPWR VPB abpmos
X37 a_110_47# A VGND VNB abnmos
X38 X a_110_47# VGND VNB abnmos
X39 X a_110_47# VGND VNB abnmos
.ends CLKBUFD8B
