* LPFLOW_DECAPKAPWRD12 : abstract conversion of sky130_fd_sc_hd__lpflow_decapkapwr_12
* 4 abstract devices (width -> parallel min-width fingers) ; secondary power ['KAPWR'] collapsed onto VPWR
.subckt LPFLOW_DECAPKAPWRD12 VGND VPWR
XLPFLOW_DECAPKAPWRD12B VPWR VGND VGND VPWR VPWR LPFLOW_DECAPKAPWRD12B
.ends LPFLOW_DECAPKAPWRD12

.subckt LPFLOW_DECAPKAPWRD12B KAPWR VGND VNB VPB VPWR
X0 KAPWR VGND KAPWR VPB abpmos
X1 KAPWR VGND KAPWR VPB abpmos
X2 VGND KAPWR VGND VNB abnmos
X3 VGND KAPWR VGND VNB abnmos
.ends LPFLOW_DECAPKAPWRD12B
