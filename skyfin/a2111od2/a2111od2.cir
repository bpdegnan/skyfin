* A2111OD2 : abstract conversion of sky130_fd_sc_hd__a2111o_2
* 35 abstract devices (width -> parallel min-width fingers)
.subckt A2111OD2 A1 A2 B1 C1 D1 VGND VPWR X
XA2111OD2B A1 A2 B1 C1 D1 VGND VGND VPWR VPWR X A2111OD2B
.ends A2111OD2

.subckt A2111OD2B A1 A2 B1 C1 D1 VGND VNB VPB VPWR X
X0 a_86_235# A1 a_715_47# VNB abnmos
X1 a_86_235# A1 a_715_47# VNB abnmos
X2 X a_86_235# VGND VNB abnmos
X3 X a_86_235# VGND VNB abnmos
X4 a_715_47# A2 VGND VNB abnmos
X5 a_715_47# A2 VGND VNB abnmos
X6 a_86_235# D1 VGND VNB abnmos
X7 a_86_235# D1 VGND VNB abnmos
X8 a_86_235# C1 VGND VNB abnmos
X9 a_86_235# C1 VGND VNB abnmos
X10 X a_86_235# VPWR VPB abpmos
X11 X a_86_235# VPWR VPB abpmos
X12 X a_86_235# VPWR VPB abpmos
X13 a_86_235# B1 VGND VNB abnmos
X14 a_86_235# B1 VGND VNB abnmos
X15 a_607_297# A2 VPWR VPB abpmos
X16 a_607_297# A2 VPWR VPB abpmos
X17 a_607_297# A2 VPWR VPB abpmos
X18 X a_86_235# VPWR VPB abpmos
X19 X a_86_235# VPWR VPB abpmos
X20 X a_86_235# VPWR VPB abpmos
X21 a_607_297# A1 VPWR VPB abpmos
X22 a_607_297# A1 VPWR VPB abpmos
X23 a_607_297# A1 VPWR VPB abpmos
X24 a_499_297# B1 a_607_297# VPB abpmos
X25 a_499_297# B1 a_607_297# VPB abpmos
X26 a_499_297# B1 a_607_297# VPB abpmos
X27 a_86_235# D1 a_427_297# VPB abpmos
X28 a_86_235# D1 a_427_297# VPB abpmos
X29 a_86_235# D1 a_427_297# VPB abpmos
X30 a_427_297# C1 a_499_297# VPB abpmos
X31 a_427_297# C1 a_499_297# VPB abpmos
X32 a_427_297# C1 a_499_297# VPB abpmos
X33 X a_86_235# VGND VNB abnmos
X34 X a_86_235# VGND VNB abnmos
.ends A2111OD2B
