* A41OD4 : abstract conversion of sky130_fd_sc_hd__a41o_4
* 70 abstract devices (width -> parallel min-width fingers)
.subckt A41OD4 A1 A2 A3 A4 B1 VGND VPWR X
XA41OD4B A1 A2 A3 A4 B1 VGND VGND VPWR VPWR X A41OD4B
.ends A41OD4

.subckt A41OD4B A1 A2 A3 A4 B1 VGND VNB VPB VPWR X
X0 a_467_297# A2 VPWR VPB abpmos
X1 a_467_297# A2 VPWR VPB abpmos
X2 a_467_297# A2 VPWR VPB abpmos
X3 a_889_47# A3 a_1079_47# VNB abnmos
X4 a_889_47# A3 a_1079_47# VNB abnmos
X5 a_639_47# A1 a_79_21# VNB abnmos
X6 a_639_47# A1 a_79_21# VNB abnmos
X7 a_467_297# A1 VPWR VPB abpmos
X8 a_467_297# A1 VPWR VPB abpmos
X9 a_467_297# A1 VPWR VPB abpmos
X10 a_467_297# A2 VPWR VPB abpmos
X11 a_467_297# A2 VPWR VPB abpmos
X12 a_467_297# A2 VPWR VPB abpmos
X13 a_1079_47# A3 a_889_47# VNB abnmos
X14 a_1079_47# A3 a_889_47# VNB abnmos
X15 a_467_297# B1 a_79_21# VPB abpmos
X16 a_467_297# B1 a_79_21# VPB abpmos
X17 a_467_297# B1 a_79_21# VPB abpmos
X18 a_467_297# A3 VPWR VPB abpmos
X19 a_467_297# A3 VPWR VPB abpmos
X20 a_467_297# A3 VPWR VPB abpmos
X21 X a_79_21# VGND VNB abnmos
X22 X a_79_21# VGND VNB abnmos
X23 a_467_297# A1 VPWR VPB abpmos
X24 a_467_297# A1 VPWR VPB abpmos
X25 a_467_297# A1 VPWR VPB abpmos
X26 a_467_297# A3 VPWR VPB abpmos
X27 a_467_297# A3 VPWR VPB abpmos
X28 a_467_297# A3 VPWR VPB abpmos
X29 a_1079_47# A4 VGND VNB abnmos
X30 a_1079_47# A4 VGND VNB abnmos
X31 a_79_21# B1 a_467_297# VPB abpmos
X32 a_79_21# B1 a_467_297# VPB abpmos
X33 a_79_21# B1 a_467_297# VPB abpmos
X34 a_889_47# A2 a_639_47# VNB abnmos
X35 a_889_47# A2 a_639_47# VNB abnmos
X36 a_79_21# B1 VGND VNB abnmos
X37 a_79_21# B1 VGND VNB abnmos
X38 X a_79_21# VGND VNB abnmos
X39 X a_79_21# VGND VNB abnmos
X40 a_467_297# A4 VPWR VPB abpmos
X41 a_467_297# A4 VPWR VPB abpmos
X42 a_467_297# A4 VPWR VPB abpmos
X43 X a_79_21# VGND VNB abnmos
X44 X a_79_21# VGND VNB abnmos
X45 X a_79_21# VPWR VPB abpmos
X46 X a_79_21# VPWR VPB abpmos
X47 X a_79_21# VPWR VPB abpmos
X48 X a_79_21# VGND VNB abnmos
X49 X a_79_21# VGND VNB abnmos
X50 X a_79_21# VPWR VPB abpmos
X51 X a_79_21# VPWR VPB abpmos
X52 X a_79_21# VPWR VPB abpmos
X53 a_467_297# A4 VPWR VPB abpmos
X54 a_467_297# A4 VPWR VPB abpmos
X55 a_467_297# A4 VPWR VPB abpmos
X56 a_639_47# A2 a_889_47# VNB abnmos
X57 a_639_47# A2 a_889_47# VNB abnmos
X58 X a_79_21# VPWR VPB abpmos
X59 X a_79_21# VPWR VPB abpmos
X60 X a_79_21# VPWR VPB abpmos
X61 a_79_21# B1 VGND VNB abnmos
X62 a_79_21# B1 VGND VNB abnmos
X63 X a_79_21# VPWR VPB abpmos
X64 X a_79_21# VPWR VPB abpmos
X65 X a_79_21# VPWR VPB abpmos
X66 a_79_21# A1 a_639_47# VNB abnmos
X67 a_79_21# A1 a_639_47# VNB abnmos
X68 a_1079_47# A4 VGND VNB abnmos
X69 a_1079_47# A4 VGND VNB abnmos
.ends A41OD4B
