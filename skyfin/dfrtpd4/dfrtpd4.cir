* DFRTPD4 : abstract conversion of sky130_fd_sc_hd__dfrtp_4
* 50 abstract devices (width -> parallel min-width fingers)
.subckt DFRTPD4 CLK D RESET_B VGND VPWR Q
XDFRTPD4B CLK D RESET_B VGND VGND VPWR VPWR Q DFRTPD4B
.ends DFRTPD4

.subckt DFRTPD4B CLK D RESET_B VGND VNB VPB VPWR Q
X0 a_1270_413# a_1283_21# VPWR VPB abpmos
X1 a_761_289# a_543_47# VPWR VPB abpmos
X2 a_761_289# a_543_47# VPWR VPB abpmos
X3 a_761_289# a_543_47# VGND VNB abnmos
X4 a_761_289# a_543_47# VGND VNB abnmos
X5 a_448_47# D VGND VNB abnmos
X6 a_1108_47# a_193_47# a_1270_413# VPB abpmos
X7 Q a_1283_21# VPWR VPB abpmos
X8 Q a_1283_21# VPWR VPB abpmos
X9 Q a_1283_21# VPWR VPB abpmos
X10 a_1217_47# a_1283_21# VGND VNB abnmos
X11 a_448_47# a_27_47# a_543_47# VNB abnmos
X12 Q a_1283_21# VGND VNB abnmos
X13 Q a_1283_21# VGND VNB abnmos
X14 a_448_47# a_193_47# a_543_47# VPB abpmos
X15 a_543_47# a_193_47# a_639_47# VNB abnmos
X16 a_1108_47# a_27_47# a_1217_47# VNB abnmos
X17 a_1462_47# a_1108_47# a_1283_21# VNB abnmos
X18 Q a_1283_21# VPWR VPB abpmos
X19 Q a_1283_21# VPWR VPB abpmos
X20 Q a_1283_21# VPWR VPB abpmos
X21 Q a_1283_21# VGND VNB abnmos
X22 Q a_1283_21# VGND VNB abnmos
X23 a_543_47# a_27_47# a_651_413# VPB abpmos
X24 a_805_47# RESET_B VGND VNB abnmos
X25 Q a_1283_21# VPWR VPB abpmos
X26 Q a_1283_21# VPWR VPB abpmos
X27 Q a_1283_21# VPWR VPB abpmos
X28 Q a_1283_21# VPWR VPB abpmos
X29 Q a_1283_21# VPWR VPB abpmos
X30 Q a_1283_21# VPWR VPB abpmos
X31 a_761_289# a_193_47# a_1108_47# VNB abnmos
X32 a_651_413# RESET_B VPWR VPB abpmos
X33 a_193_47# a_27_47# VGND VNB abnmos
X34 a_27_47# CLK VGND VNB abnmos
X35 Q a_1283_21# VGND VNB abnmos
X36 Q a_1283_21# VGND VNB abnmos
X37 a_27_47# CLK VPWR VPB abpmos
X38 a_27_47# CLK VPWR VPB abpmos
X39 a_193_47# a_27_47# VPWR VPB abpmos
X40 a_193_47# a_27_47# VPWR VPB abpmos
X41 a_1283_21# a_1108_47# VPWR VPB abpmos
X42 a_1462_47# RESET_B VGND VNB abnmos
X43 a_448_47# D VPWR VPB abpmos
X44 Q a_1283_21# VGND VNB abnmos
X45 Q a_1283_21# VGND VNB abnmos
X46 a_651_413# a_761_289# VPWR VPB abpmos
X47 a_761_289# a_27_47# a_1108_47# VPB abpmos
X48 a_1283_21# RESET_B VPWR VPB abpmos
X49 a_639_47# a_761_289# a_805_47# VNB abnmos
.ends DFRTPD4B
