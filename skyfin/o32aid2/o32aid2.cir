* O32AID2 : abstract conversion of sky130_fd_sc_hd__o32ai_2
* 50 abstract devices (width -> parallel min-width fingers)
.subckt O32AID2 A1 A2 A3 B1 B2 VGND VPWR Y
XO32AID2B A1 A2 A3 B1 B2 VGND VGND VPWR VPWR Y O32AID2B
.ends O32AID2

.subckt O32AID2B A1 A2 A3 B1 B2 VGND VNB VPB VPWR Y
X0 a_27_47# A3 VGND VNB abnmos
X1 a_27_47# A3 VGND VNB abnmos
X2 a_729_297# A1 VPWR VPB abpmos
X3 a_729_297# A1 VPWR VPB abpmos
X4 a_729_297# A1 VPWR VPB abpmos
X5 a_27_47# A2 VGND VNB abnmos
X6 a_27_47# A2 VGND VNB abnmos
X7 a_27_47# A3 VGND VNB abnmos
X8 a_27_47# A3 VGND VNB abnmos
X9 Y B1 a_27_47# VNB abnmos
X10 Y B1 a_27_47# VNB abnmos
X11 Y A3 a_475_297# VPB abpmos
X12 Y A3 a_475_297# VPB abpmos
X13 Y A3 a_475_297# VPB abpmos
X14 a_475_297# A3 Y VPB abpmos
X15 a_475_297# A3 Y VPB abpmos
X16 a_475_297# A3 Y VPB abpmos
X17 a_27_47# A2 VGND VNB abnmos
X18 a_27_47# A2 VGND VNB abnmos
X19 a_27_47# A1 VGND VNB abnmos
X20 a_27_47# A1 VGND VNB abnmos
X21 a_729_297# A1 VPWR VPB abpmos
X22 a_729_297# A1 VPWR VPB abpmos
X23 a_729_297# A1 VPWR VPB abpmos
X24 a_27_47# B1 Y VNB abnmos
X25 a_27_47# B1 Y VNB abnmos
X26 a_475_297# A2 a_729_297# VPB abpmos
X27 a_475_297# A2 a_729_297# VPB abpmos
X28 a_475_297# A2 a_729_297# VPB abpmos
X29 Y B2 a_27_47# VNB abnmos
X30 Y B2 a_27_47# VNB abnmos
X31 a_27_47# A1 VGND VNB abnmos
X32 a_27_47# A1 VGND VNB abnmos
X33 a_27_297# B1 VPWR VPB abpmos
X34 a_27_297# B1 VPWR VPB abpmos
X35 a_27_297# B1 VPWR VPB abpmos
X36 a_27_47# B2 Y VNB abnmos
X37 a_27_47# B2 Y VNB abnmos
X38 a_729_297# A2 a_475_297# VPB abpmos
X39 a_729_297# A2 a_475_297# VPB abpmos
X40 a_729_297# A2 a_475_297# VPB abpmos
X41 a_27_297# B2 Y VPB abpmos
X42 a_27_297# B2 Y VPB abpmos
X43 a_27_297# B2 Y VPB abpmos
X44 Y B2 a_27_297# VPB abpmos
X45 Y B2 a_27_297# VPB abpmos
X46 Y B2 a_27_297# VPB abpmos
X47 a_27_297# B1 VPWR VPB abpmos
X48 a_27_297# B1 VPWR VPB abpmos
X49 a_27_297# B1 VPWR VPB abpmos
.ends O32AID2B
