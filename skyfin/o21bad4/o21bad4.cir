* O21BAD4 : abstract conversion of sky130_fd_sc_hd__o21ba_4
* 55 abstract devices (width -> parallel min-width fingers)
.subckt O21BAD4 A1 A2 B1_N VGND VPWR X
XO21BAD4B A1 A2 B1_N VGND VGND VPWR VPWR X O21BAD4B
.ends O21BAD4

.subckt O21BAD4B A1 A2 B1_N VGND VNB VPB VPWR X
X0 a_575_47# A1 VGND VNB abnmos
X1 a_575_47# A1 VGND VNB abnmos
X2 X a_187_21# VGND VNB abnmos
X3 X a_187_21# VGND VNB abnmos
X4 a_27_297# B1_N VPWR VPB abpmos
X5 a_27_297# B1_N VPWR VPB abpmos
X6 a_27_297# B1_N VPWR VPB abpmos
X7 a_743_297# A1 VPWR VPB abpmos
X8 a_743_297# A1 VPWR VPB abpmos
X9 a_743_297# A1 VPWR VPB abpmos
X10 a_187_21# a_27_297# a_575_47# VNB abnmos
X11 a_187_21# a_27_297# a_575_47# VNB abnmos
X12 a_575_47# A2 VGND VNB abnmos
X13 a_575_47# A2 VGND VNB abnmos
X14 X a_187_21# VPWR VPB abpmos
X15 X a_187_21# VPWR VPB abpmos
X16 X a_187_21# VPWR VPB abpmos
X17 a_187_21# A2 a_743_297# VPB abpmos
X18 a_187_21# A2 a_743_297# VPB abpmos
X19 a_187_21# A2 a_743_297# VPB abpmos
X20 X a_187_21# VGND VNB abnmos
X21 X a_187_21# VGND VNB abnmos
X22 a_575_47# A1 VGND VNB abnmos
X23 a_575_47# A1 VGND VNB abnmos
X24 a_187_21# a_27_297# VPWR VPB abpmos
X25 a_187_21# a_27_297# VPWR VPB abpmos
X26 a_187_21# a_27_297# VPWR VPB abpmos
X27 a_575_47# A2 VGND VNB abnmos
X28 a_575_47# A2 VGND VNB abnmos
X29 X a_187_21# VPWR VPB abpmos
X30 X a_187_21# VPWR VPB abpmos
X31 X a_187_21# VPWR VPB abpmos
X32 X a_187_21# VPWR VPB abpmos
X33 X a_187_21# VPWR VPB abpmos
X34 X a_187_21# VPWR VPB abpmos
X35 a_743_297# A2 a_187_21# VPB abpmos
X36 a_743_297# A2 a_187_21# VPB abpmos
X37 a_743_297# A2 a_187_21# VPB abpmos
X38 X a_187_21# VGND VNB abnmos
X39 X a_187_21# VGND VNB abnmos
X40 a_575_47# a_27_297# a_187_21# VNB abnmos
X41 a_575_47# a_27_297# a_187_21# VNB abnmos
X42 a_743_297# A1 VPWR VPB abpmos
X43 a_743_297# A1 VPWR VPB abpmos
X44 a_743_297# A1 VPWR VPB abpmos
X45 a_187_21# a_27_297# VPWR VPB abpmos
X46 a_187_21# a_27_297# VPWR VPB abpmos
X47 a_187_21# a_27_297# VPWR VPB abpmos
X48 X a_187_21# VPWR VPB abpmos
X49 X a_187_21# VPWR VPB abpmos
X50 X a_187_21# VPWR VPB abpmos
X51 X a_187_21# VGND VNB abnmos
X52 X a_187_21# VGND VNB abnmos
X53 a_27_297# B1_N VGND VNB abnmos
X54 a_27_297# B1_N VGND VNB abnmos
.ends O21BAD4B
