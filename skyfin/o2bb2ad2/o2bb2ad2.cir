* O2BB2AD2 : abstract conversion of sky130_fd_sc_hd__o2bb2a_2
* 25 abstract devices (width -> parallel min-width fingers)
.subckt O2BB2AD2 A1_N A2_N B1 B2 VGND VPWR X
XO2BB2AD2B A1_N A2_N B1 B2 VGND VGND VPWR VPWR X O2BB2AD2B
.ends O2BB2AD2

.subckt O2BB2AD2B A1_N A2_N B1 B2 VGND VNB VPB VPWR X
X0 a_295_369# A1_N VPWR VPB abpmos
X1 a_295_369# A1_N VPWR VPB abpmos
X2 a_295_369# A2_N VPWR VPB abpmos
X3 a_295_369# A2_N VPWR VPB abpmos
X4 a_581_47# B2 VGND VNB abnmos
X5 X a_84_21# VGND VNB abnmos
X6 X a_84_21# VGND VNB abnmos
X7 a_294_47# A2_N a_295_369# VNB abnmos
X8 a_294_47# A1_N VGND VNB abnmos
X9 X a_84_21# VPWR VPB abpmos
X10 X a_84_21# VPWR VPB abpmos
X11 X a_84_21# VPWR VPB abpmos
X12 a_84_21# a_295_369# a_581_47# VNB abnmos
X13 X a_84_21# VGND VNB abnmos
X14 X a_84_21# VGND VNB abnmos
X15 a_84_21# a_295_369# VPWR VPB abpmos
X16 a_84_21# a_295_369# VPWR VPB abpmos
X17 X a_84_21# VPWR VPB abpmos
X18 X a_84_21# VPWR VPB abpmos
X19 X a_84_21# VPWR VPB abpmos
X20 a_665_369# B1 VPWR VPB abpmos
X21 a_665_369# B1 VPWR VPB abpmos
X22 a_84_21# B2 a_665_369# VPB abpmos
X23 a_84_21# B2 a_665_369# VPB abpmos
X24 a_581_47# B1 VGND VNB abnmos
.ends O2BB2AD2B
