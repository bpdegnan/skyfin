* NAND4BBD4 : abstract conversion of sky130_fd_sc_hd__nand4bb_4
* 90 abstract devices (width -> parallel min-width fingers)
.subckt NAND4BBD4 A_N B_N C D VGND VPWR Y
XNAND4BBD4B A_N B_N C D VGND VGND VPWR VPWR Y NAND4BBD4B
.ends NAND4BBD4

.subckt NAND4BBD4B A_N B_N C D VGND VNB VPB VPWR Y
X0 a_1266_47# D VGND VNB abnmos
X1 a_1266_47# D VGND VNB abnmos
X2 Y a_27_47# VPWR VPB abpmos
X3 Y a_27_47# VPWR VPB abpmos
X4 Y a_27_47# VPWR VPB abpmos
X5 Y a_27_47# VPWR VPB abpmos
X6 Y a_27_47# VPWR VPB abpmos
X7 Y a_27_47# VPWR VPB abpmos
X8 a_432_47# a_27_47# Y VNB abnmos
X9 a_432_47# a_27_47# Y VNB abnmos
X10 a_432_47# a_193_47# a_850_47# VNB abnmos
X11 a_432_47# a_193_47# a_850_47# VNB abnmos
X12 Y a_193_47# VPWR VPB abpmos
X13 Y a_193_47# VPWR VPB abpmos
X14 Y a_193_47# VPWR VPB abpmos
X15 a_1266_47# D VGND VNB abnmos
X16 a_1266_47# D VGND VNB abnmos
X17 Y a_27_47# VPWR VPB abpmos
X18 Y a_27_47# VPWR VPB abpmos
X19 Y a_27_47# VPWR VPB abpmos
X20 Y C VPWR VPB abpmos
X21 Y C VPWR VPB abpmos
X22 Y C VPWR VPB abpmos
X23 Y a_27_47# VPWR VPB abpmos
X24 Y a_27_47# VPWR VPB abpmos
X25 Y a_27_47# VPWR VPB abpmos
X26 Y a_193_47# VPWR VPB abpmos
X27 Y a_193_47# VPWR VPB abpmos
X28 Y a_193_47# VPWR VPB abpmos
X29 a_432_47# a_193_47# a_850_47# VNB abnmos
X30 a_432_47# a_193_47# a_850_47# VNB abnmos
X31 a_1266_47# D VGND VNB abnmos
X32 a_1266_47# D VGND VNB abnmos
X33 Y C VPWR VPB abpmos
X34 Y C VPWR VPB abpmos
X35 Y C VPWR VPB abpmos
X36 Y a_193_47# VPWR VPB abpmos
X37 Y a_193_47# VPWR VPB abpmos
X38 Y a_193_47# VPWR VPB abpmos
X39 Y a_27_47# a_432_47# VNB abnmos
X40 Y a_27_47# a_432_47# VNB abnmos
X41 a_850_47# a_193_47# a_432_47# VNB abnmos
X42 a_850_47# a_193_47# a_432_47# VNB abnmos
X43 Y a_193_47# VPWR VPB abpmos
X44 Y a_193_47# VPWR VPB abpmos
X45 Y a_193_47# VPWR VPB abpmos
X46 a_432_47# a_27_47# Y VNB abnmos
X47 a_432_47# a_27_47# Y VNB abnmos
X48 Y D VPWR VPB abpmos
X49 Y D VPWR VPB abpmos
X50 Y D VPWR VPB abpmos
X51 a_850_47# C a_1266_47# VNB abnmos
X52 a_850_47# C a_1266_47# VNB abnmos
X53 a_1266_47# D VGND VNB abnmos
X54 a_1266_47# D VGND VNB abnmos
X55 Y C VPWR VPB abpmos
X56 Y C VPWR VPB abpmos
X57 Y C VPWR VPB abpmos
X58 a_850_47# C a_1266_47# VNB abnmos
X59 a_850_47# C a_1266_47# VNB abnmos
X60 Y D VPWR VPB abpmos
X61 Y D VPWR VPB abpmos
X62 Y D VPWR VPB abpmos
X63 a_193_47# B_N VGND VNB abnmos
X64 a_193_47# B_N VGND VNB abnmos
X65 a_27_47# A_N VGND VNB abnmos
X66 a_27_47# A_N VGND VNB abnmos
X67 a_1266_47# C a_850_47# VNB abnmos
X68 a_1266_47# C a_850_47# VNB abnmos
X69 Y D VPWR VPB abpmos
X70 Y D VPWR VPB abpmos
X71 Y D VPWR VPB abpmos
X72 Y C VPWR VPB abpmos
X73 Y C VPWR VPB abpmos
X74 Y C VPWR VPB abpmos
X75 a_1266_47# C a_850_47# VNB abnmos
X76 a_1266_47# C a_850_47# VNB abnmos
X77 a_27_47# A_N VPWR VPB abpmos
X78 a_27_47# A_N VPWR VPB abpmos
X79 a_27_47# A_N VPWR VPB abpmos
X80 Y D VPWR VPB abpmos
X81 Y D VPWR VPB abpmos
X82 Y D VPWR VPB abpmos
X83 a_193_47# B_N VPWR VPB abpmos
X84 a_193_47# B_N VPWR VPB abpmos
X85 a_193_47# B_N VPWR VPB abpmos
X86 Y a_27_47# a_432_47# VNB abnmos
X87 Y a_27_47# a_432_47# VNB abnmos
X88 a_850_47# a_193_47# a_432_47# VNB abnmos
X89 a_850_47# a_193_47# a_432_47# VNB abnmos
.ends NAND4BBD4B
