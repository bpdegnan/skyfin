* A41OID2 : abstract conversion of sky130_fd_sc_hd__a41oi_2
* 50 abstract devices (width -> parallel min-width fingers)
.subckt A41OID2 A1 A2 A3 A4 B1 VGND VPWR Y
XA41OID2B A1 A2 A3 A4 B1 VGND VGND VPWR VPWR Y A41OID2B
.ends A41OID2

.subckt A41OID2B A1 A2 A3 A4 B1 VGND VNB VPB VPWR Y
X0 a_317_47# A1 Y VNB abnmos
X1 a_317_47# A1 Y VNB abnmos
X2 a_149_297# B1 Y VPB abpmos
X3 a_149_297# B1 Y VPB abpmos
X4 a_149_297# B1 Y VPB abpmos
X5 a_567_47# A2 a_317_47# VNB abnmos
X6 a_567_47# A2 a_317_47# VNB abnmos
X7 a_149_297# A4 VPWR VPB abpmos
X8 a_149_297# A4 VPWR VPB abpmos
X9 a_149_297# A4 VPWR VPB abpmos
X10 a_149_297# A1 VPWR VPB abpmos
X11 a_149_297# A1 VPWR VPB abpmos
X12 a_149_297# A1 VPWR VPB abpmos
X13 a_149_297# A2 VPWR VPB abpmos
X14 a_149_297# A2 VPWR VPB abpmos
X15 a_149_297# A2 VPWR VPB abpmos
X16 a_149_297# A4 VPWR VPB abpmos
X17 a_149_297# A4 VPWR VPB abpmos
X18 a_149_297# A4 VPWR VPB abpmos
X19 a_757_47# A4 VGND VNB abnmos
X20 a_757_47# A4 VGND VNB abnmos
X21 Y B1 a_149_297# VPB abpmos
X22 Y B1 a_149_297# VPB abpmos
X23 Y B1 a_149_297# VPB abpmos
X24 a_149_297# A1 VPWR VPB abpmos
X25 a_149_297# A1 VPWR VPB abpmos
X26 a_149_297# A1 VPWR VPB abpmos
X27 a_149_297# A3 VPWR VPB abpmos
X28 a_149_297# A3 VPWR VPB abpmos
X29 a_149_297# A3 VPWR VPB abpmos
X30 a_317_47# A2 a_567_47# VNB abnmos
X31 a_317_47# A2 a_567_47# VNB abnmos
X32 a_757_47# A3 a_567_47# VNB abnmos
X33 a_757_47# A3 a_567_47# VNB abnmos
X34 a_149_297# A2 VPWR VPB abpmos
X35 a_149_297# A2 VPWR VPB abpmos
X36 a_149_297# A2 VPWR VPB abpmos
X37 a_567_47# A3 a_757_47# VNB abnmos
X38 a_567_47# A3 a_757_47# VNB abnmos
X39 a_149_297# A3 VPWR VPB abpmos
X40 a_149_297# A3 VPWR VPB abpmos
X41 a_149_297# A3 VPWR VPB abpmos
X42 Y B1 VGND VNB abnmos
X43 Y B1 VGND VNB abnmos
X44 Y A1 a_317_47# VNB abnmos
X45 Y A1 a_317_47# VNB abnmos
X46 a_757_47# A4 VGND VNB abnmos
X47 a_757_47# A4 VGND VNB abnmos
X48 Y B1 VGND VNB abnmos
X49 Y B1 VGND VNB abnmos
.ends A41OID2B
