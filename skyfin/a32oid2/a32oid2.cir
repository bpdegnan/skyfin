* A32OID2 : abstract conversion of sky130_fd_sc_hd__a32oi_2
* 50 abstract devices (width -> parallel min-width fingers)
.subckt A32OID2 A1 A2 A3 B1 B2 VGND VPWR Y
XA32OID2B A1 A2 A3 B1 B2 VGND VGND VPWR VPWR Y A32OID2B
.ends A32OID2

.subckt A32OID2B A1 A2 A3 B1 B2 VGND VNB VPB VPWR Y
X0 a_730_47# A2 a_478_47# VNB abnmos
X1 a_730_47# A2 a_478_47# VNB abnmos
X2 Y B1 a_27_47# VNB abnmos
X3 Y B1 a_27_47# VNB abnmos
X4 a_27_297# A1 VPWR VPB abpmos
X5 a_27_297# A1 VPWR VPB abpmos
X6 a_27_297# A1 VPWR VPB abpmos
X7 a_27_297# A3 VPWR VPB abpmos
X8 a_27_297# A3 VPWR VPB abpmos
X9 a_27_297# A3 VPWR VPB abpmos
X10 a_27_297# A2 VPWR VPB abpmos
X11 a_27_297# A2 VPWR VPB abpmos
X12 a_27_297# A2 VPWR VPB abpmos
X13 a_27_47# B1 Y VNB abnmos
X14 a_27_47# B1 Y VNB abnmos
X15 a_27_297# A3 VPWR VPB abpmos
X16 a_27_297# A3 VPWR VPB abpmos
X17 a_27_297# A3 VPWR VPB abpmos
X18 a_27_297# A2 VPWR VPB abpmos
X19 a_27_297# A2 VPWR VPB abpmos
X20 a_27_297# A2 VPWR VPB abpmos
X21 a_27_47# B2 VGND VNB abnmos
X22 a_27_47# B2 VGND VNB abnmos
X23 Y A1 a_478_47# VNB abnmos
X24 Y A1 a_478_47# VNB abnmos
X25 a_730_47# A3 VGND VNB abnmos
X26 a_730_47# A3 VGND VNB abnmos
X27 a_27_297# B1 Y VPB abpmos
X28 a_27_297# B1 Y VPB abpmos
X29 a_27_297# B1 Y VPB abpmos
X30 a_27_47# B2 VGND VNB abnmos
X31 a_27_47# B2 VGND VNB abnmos
X32 a_478_47# A2 a_730_47# VNB abnmos
X33 a_478_47# A2 a_730_47# VNB abnmos
X34 a_730_47# A3 VGND VNB abnmos
X35 a_730_47# A3 VGND VNB abnmos
X36 a_27_297# A1 VPWR VPB abpmos
X37 a_27_297# A1 VPWR VPB abpmos
X38 a_27_297# A1 VPWR VPB abpmos
X39 a_27_297# B2 Y VPB abpmos
X40 a_27_297# B2 Y VPB abpmos
X41 a_27_297# B2 Y VPB abpmos
X42 a_478_47# A1 Y VNB abnmos
X43 a_478_47# A1 Y VNB abnmos
X44 Y B2 a_27_297# VPB abpmos
X45 Y B2 a_27_297# VPB abpmos
X46 Y B2 a_27_297# VPB abpmos
X47 Y B1 a_27_297# VPB abpmos
X48 Y B1 a_27_297# VPB abpmos
X49 Y B1 a_27_297# VPB abpmos
.ends A32OID2B
