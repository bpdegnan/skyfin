* NOR2D8 : abstract conversion of sky130_fd_sc_hd__nor2_8
* 80 abstract devices (width -> parallel min-width fingers)
.subckt NOR2D8 A B VGND VPWR Y
XNOR2D8B A B VGND VGND VPWR VPWR Y NOR2D8B
.ends NOR2D8

.subckt NOR2D8B A B VGND VNB VPB VPWR Y
X0 a_27_297# A VPWR VPB abpmos
X1 a_27_297# A VPWR VPB abpmos
X2 a_27_297# A VPWR VPB abpmos
X3 Y A VGND VNB abnmos
X4 Y A VGND VNB abnmos
X5 a_27_297# A VPWR VPB abpmos
X6 a_27_297# A VPWR VPB abpmos
X7 a_27_297# A VPWR VPB abpmos
X8 Y B VGND VNB abnmos
X9 Y B VGND VNB abnmos
X10 a_27_297# A VPWR VPB abpmos
X11 a_27_297# A VPWR VPB abpmos
X12 a_27_297# A VPWR VPB abpmos
X13 a_27_297# A VPWR VPB abpmos
X14 a_27_297# A VPWR VPB abpmos
X15 a_27_297# A VPWR VPB abpmos
X16 Y A VGND VNB abnmos
X17 Y A VGND VNB abnmos
X18 Y B a_27_297# VPB abpmos
X19 Y B a_27_297# VPB abpmos
X20 Y B a_27_297# VPB abpmos
X21 Y B VGND VNB abnmos
X22 Y B VGND VNB abnmos
X23 Y B VGND VNB abnmos
X24 Y B VGND VNB abnmos
X25 a_27_297# A VPWR VPB abpmos
X26 a_27_297# A VPWR VPB abpmos
X27 a_27_297# A VPWR VPB abpmos
X28 Y B VGND VNB abnmos
X29 Y B VGND VNB abnmos
X30 a_27_297# A VPWR VPB abpmos
X31 a_27_297# A VPWR VPB abpmos
X32 a_27_297# A VPWR VPB abpmos
X33 Y A VGND VNB abnmos
X34 Y A VGND VNB abnmos
X35 Y B VGND VNB abnmos
X36 Y B VGND VNB abnmos
X37 Y B VGND VNB abnmos
X38 Y B VGND VNB abnmos
X39 Y B a_27_297# VPB abpmos
X40 Y B a_27_297# VPB abpmos
X41 Y B a_27_297# VPB abpmos
X42 Y A VGND VNB abnmos
X43 Y A VGND VNB abnmos
X44 a_27_297# A VPWR VPB abpmos
X45 a_27_297# A VPWR VPB abpmos
X46 a_27_297# A VPWR VPB abpmos
X47 Y A VGND VNB abnmos
X48 Y A VGND VNB abnmos
X49 Y A VGND VNB abnmos
X50 Y A VGND VNB abnmos
X51 a_27_297# B Y VPB abpmos
X52 a_27_297# B Y VPB abpmos
X53 a_27_297# B Y VPB abpmos
X54 a_27_297# B Y VPB abpmos
X55 a_27_297# B Y VPB abpmos
X56 a_27_297# B Y VPB abpmos
X57 a_27_297# B Y VPB abpmos
X58 a_27_297# B Y VPB abpmos
X59 a_27_297# B Y VPB abpmos
X60 a_27_297# A VPWR VPB abpmos
X61 a_27_297# A VPWR VPB abpmos
X62 a_27_297# A VPWR VPB abpmos
X63 Y B a_27_297# VPB abpmos
X64 Y B a_27_297# VPB abpmos
X65 Y B a_27_297# VPB abpmos
X66 Y B VGND VNB abnmos
X67 Y B VGND VNB abnmos
X68 Y B a_27_297# VPB abpmos
X69 Y B a_27_297# VPB abpmos
X70 Y B a_27_297# VPB abpmos
X71 a_27_297# B Y VPB abpmos
X72 a_27_297# B Y VPB abpmos
X73 a_27_297# B Y VPB abpmos
X74 Y A VGND VNB abnmos
X75 Y A VGND VNB abnmos
X76 Y B VGND VNB abnmos
X77 Y B VGND VNB abnmos
X78 Y A VGND VNB abnmos
X79 Y A VGND VNB abnmos
.ends NOR2D8B
