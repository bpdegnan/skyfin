* A41OID1 : abstract conversion of sky130_fd_sc_hd__a41oi_1
* 25 abstract devices (width -> parallel min-width fingers)
.subckt A41OID1 A1 A2 A3 A4 B1 VGND VPWR Y
XA41OID1B A1 A2 A3 A4 B1 VGND VGND VPWR VPWR Y A41OID1B
.ends A41OID1

.subckt A41OID1B A1 A2 A3 A4 B1 VGND VNB VPB VPWR Y
X0 a_336_47# A2 a_428_47# VNB abnmos
X1 a_336_47# A2 a_428_47# VNB abnmos
X2 a_109_297# A4 VPWR VPB abpmos
X3 a_109_297# A4 VPWR VPB abpmos
X4 a_109_297# A4 VPWR VPB abpmos
X5 a_236_47# A3 a_336_47# VNB abnmos
X6 a_236_47# A3 a_336_47# VNB abnmos
X7 a_428_47# A1 Y VNB abnmos
X8 a_428_47# A1 Y VNB abnmos
X9 a_236_47# A4 VGND VNB abnmos
X10 a_236_47# A4 VGND VNB abnmos
X11 Y B1 VGND VNB abnmos
X12 Y B1 VGND VNB abnmos
X13 Y B1 a_109_297# VPB abpmos
X14 Y B1 a_109_297# VPB abpmos
X15 Y B1 a_109_297# VPB abpmos
X16 a_109_297# A3 VPWR VPB abpmos
X17 a_109_297# A3 VPWR VPB abpmos
X18 a_109_297# A3 VPWR VPB abpmos
X19 a_109_297# A2 VPWR VPB abpmos
X20 a_109_297# A2 VPWR VPB abpmos
X21 a_109_297# A2 VPWR VPB abpmos
X22 a_109_297# A1 VPWR VPB abpmos
X23 a_109_297# A1 VPWR VPB abpmos
X24 a_109_297# A1 VPWR VPB abpmos
.ends A41OID1B
