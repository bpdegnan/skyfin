* A311OID2 : abstract conversion of sky130_fd_sc_hd__a311oi_2
* 50 abstract devices (width -> parallel min-width fingers)
.subckt A311OID2 A1 A2 A3 B1 C1 VGND VPWR Y
XA311OID2B A1 A2 A3 B1 C1 VGND VGND VPWR VPWR Y A311OID2B
.ends A311OID2

.subckt A311OID2B A1 A2 A3 B1 C1 VGND VNB VPB VPWR Y
X0 a_109_297# A2 VPWR VPB abpmos
X1 a_109_297# A2 VPWR VPB abpmos
X2 a_109_297# A2 VPWR VPB abpmos
X3 Y C1 a_641_297# VPB abpmos
X4 Y C1 a_641_297# VPB abpmos
X5 Y C1 a_641_297# VPB abpmos
X6 a_277_47# A1 Y VNB abnmos
X7 a_277_47# A1 Y VNB abnmos
X8 a_109_297# B1 a_641_297# VPB abpmos
X9 a_109_297# B1 a_641_297# VPB abpmos
X10 a_109_297# B1 a_641_297# VPB abpmos
X11 a_277_47# A2 a_27_47# VNB abnmos
X12 a_277_47# A2 a_27_47# VNB abnmos
X13 a_109_297# A1 VPWR VPB abpmos
X14 a_109_297# A1 VPWR VPB abpmos
X15 a_109_297# A1 VPWR VPB abpmos
X16 a_641_297# B1 a_109_297# VPB abpmos
X17 a_641_297# B1 a_109_297# VPB abpmos
X18 a_641_297# B1 a_109_297# VPB abpmos
X19 a_109_297# A1 VPWR VPB abpmos
X20 a_109_297# A1 VPWR VPB abpmos
X21 a_109_297# A1 VPWR VPB abpmos
X22 Y B1 VGND VNB abnmos
X23 Y B1 VGND VNB abnmos
X24 Y B1 VGND VNB abnmos
X25 Y B1 VGND VNB abnmos
X26 a_27_47# A2 a_277_47# VNB abnmos
X27 a_27_47# A2 a_277_47# VNB abnmos
X28 Y A1 a_277_47# VNB abnmos
X29 Y A1 a_277_47# VNB abnmos
X30 Y C1 VGND VNB abnmos
X31 Y C1 VGND VNB abnmos
X32 a_27_47# A3 VGND VNB abnmos
X33 a_27_47# A3 VGND VNB abnmos
X34 a_109_297# A2 VPWR VPB abpmos
X35 a_109_297# A2 VPWR VPB abpmos
X36 a_109_297# A2 VPWR VPB abpmos
X37 a_641_297# C1 Y VPB abpmos
X38 a_641_297# C1 Y VPB abpmos
X39 a_641_297# C1 Y VPB abpmos
X40 a_27_47# A3 VGND VNB abnmos
X41 a_27_47# A3 VGND VNB abnmos
X42 a_109_297# A3 VPWR VPB abpmos
X43 a_109_297# A3 VPWR VPB abpmos
X44 a_109_297# A3 VPWR VPB abpmos
X45 a_109_297# A3 VPWR VPB abpmos
X46 a_109_297# A3 VPWR VPB abpmos
X47 a_109_297# A3 VPWR VPB abpmos
X48 Y C1 VGND VNB abnmos
X49 Y C1 VGND VNB abnmos
.ends A311OID2B
