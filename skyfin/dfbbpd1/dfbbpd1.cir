* DFBBPD1 : abstract conversion of sky130_fd_sc_hd__dfbbp_1
* 60 abstract devices (width -> parallel min-width fingers)
.subckt DFBBPD1 CLK D RESET_B SET_B VGND VPWR Q Q_N
XDFBBPD1B CLK D RESET_B SET_B VGND VGND VPWR VPWR Q Q_N DFBBPD1B
.ends DFBBPD1

.subckt DFBBPD1B CLK D RESET_B SET_B VGND VNB VPB VPWR Q Q_N
X0 a_1364_47# a_1429_21# VGND VNB abnmos
X1 a_2136_47# a_1429_21# VPWR VPB abpmos
X2 a_2136_47# a_1429_21# VPWR VPB abpmos
X3 a_1545_47# SET_B VGND VNB abnmos
X4 a_788_47# a_474_413# a_648_21# VNB abnmos
X5 a_788_47# a_474_413# a_648_21# VNB abnmos
X6 a_1255_47# a_193_47# a_1341_413# VPB abpmos
X7 a_381_47# a_27_47# a_474_413# VNB abnmos
X8 a_381_47# D VPWR VPB abpmos
X9 a_648_21# SET_B VPWR VPB abpmos
X10 a_1113_329# a_648_21# VPWR VPB abpmos
X11 a_1113_329# a_648_21# VPWR VPB abpmos
X12 a_942_21# RESET_B VPWR VPB abpmos
X13 a_942_21# RESET_B VPWR VPB abpmos
X14 a_2136_47# a_1429_21# VGND VNB abnmos
X15 a_892_329# a_942_21# VPWR VPB abpmos
X16 a_892_329# a_942_21# VPWR VPB abpmos
X17 a_1429_21# SET_B VPWR VPB abpmos
X18 a_788_47# SET_B VGND VNB abnmos
X19 a_1160_47# a_648_21# VGND VNB abnmos
X20 a_1160_47# a_648_21# VGND VNB abnmos
X21 a_558_413# a_648_21# VPWR VPB abpmos
X22 a_648_21# a_474_413# a_892_329# VPB abpmos
X23 a_648_21# a_474_413# a_892_329# VPB abpmos
X24 a_1341_413# a_1429_21# VPWR VPB abpmos
X25 Q a_2136_47# VGND VNB abnmos
X26 Q a_2136_47# VGND VNB abnmos
X27 Q_N a_1429_21# VGND VNB abnmos
X28 Q_N a_1429_21# VGND VNB abnmos
X29 a_1255_47# a_27_47# a_1364_47# VNB abnmos
X30 a_474_413# a_27_47# a_558_413# VPB abpmos
X31 a_193_47# a_27_47# VGND VNB abnmos
X32 Q a_2136_47# VPWR VPB abpmos
X33 Q a_2136_47# VPWR VPB abpmos
X34 Q a_2136_47# VPWR VPB abpmos
X35 a_27_47# CLK VGND VNB abnmos
X36 a_648_21# a_942_21# a_788_47# VNB abnmos
X37 a_648_21# a_942_21# a_788_47# VNB abnmos
X38 a_27_47# CLK VPWR VPB abpmos
X39 a_27_47# CLK VPWR VPB abpmos
X40 a_1429_21# a_1255_47# a_1663_329# VPB abpmos
X41 a_1429_21# a_1255_47# a_1663_329# VPB abpmos
X42 a_1663_329# a_942_21# VPWR VPB abpmos
X43 a_1663_329# a_942_21# VPWR VPB abpmos
X44 a_1429_21# a_942_21# a_1545_47# VNB abnmos
X45 a_1429_21# a_942_21# a_1545_47# VNB abnmos
X46 a_193_47# a_27_47# VPWR VPB abpmos
X47 a_193_47# a_27_47# VPWR VPB abpmos
X48 a_381_47# a_193_47# a_474_413# VPB abpmos
X49 a_381_47# D VGND VNB abnmos
X50 a_1160_47# a_193_47# a_1255_47# VNB abnmos
X51 a_474_413# a_193_47# a_582_47# VNB abnmos
X52 a_1545_47# a_1255_47# a_1429_21# VNB abnmos
X53 a_1545_47# a_1255_47# a_1429_21# VNB abnmos
X54 a_942_21# RESET_B VGND VNB abnmos
X55 a_1113_329# a_27_47# a_1255_47# VPB abpmos
X56 a_582_47# a_648_21# VGND VNB abnmos
X57 Q_N a_1429_21# VPWR VPB abpmos
X58 Q_N a_1429_21# VPWR VPB abpmos
X59 Q_N a_1429_21# VPWR VPB abpmos
.ends DFBBPD1B
