* CLKDLYBUF4S18D2 : abstract conversion of sky130_fd_sc_hd__clkdlybuf4s18_2
* 20 abstract devices (width -> parallel min-width fingers)
.subckt CLKDLYBUF4S18D2 A VGND VPWR X
XCLKDLYBUF4S18D2B A VGND VGND VPWR VPWR X CLKDLYBUF4S18D2B
.ends CLKDLYBUF4S18D2

.subckt CLKDLYBUF4S18D2B A VGND VNB VPB VPWR X
X0 a_334_47# a_227_47# VPWR VPB abpmos
X1 a_334_47# a_227_47# VPWR VPB abpmos
X2 a_227_47# a_27_47# VPWR VPB abpmos
X3 a_227_47# a_27_47# VPWR VPB abpmos
X4 X a_334_47# VPWR VPB abpmos
X5 X a_334_47# VPWR VPB abpmos
X6 X a_334_47# VPWR VPB abpmos
X7 a_27_47# A VPWR VPB abpmos
X8 a_27_47# A VPWR VPB abpmos
X9 a_27_47# A VPWR VPB abpmos
X10 X a_334_47# VPWR VPB abpmos
X11 X a_334_47# VPWR VPB abpmos
X12 X a_334_47# VPWR VPB abpmos
X13 a_334_47# a_227_47# VGND VNB abnmos
X14 a_334_47# a_227_47# VGND VNB abnmos
X15 a_227_47# a_27_47# VGND VNB abnmos
X16 a_227_47# a_27_47# VGND VNB abnmos
X17 X a_334_47# VGND VNB abnmos
X18 X a_334_47# VGND VNB abnmos
X19 a_27_47# A VGND VNB abnmos
.ends CLKDLYBUF4S18D2B
