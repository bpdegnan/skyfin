* O2111AD4 : abstract conversion of sky130_fd_sc_hd__o2111a_4
* 70 abstract devices (width -> parallel min-width fingers)
.subckt O2111AD4 A1 A2 B1 C1 D1 VGND VPWR X
XO2111AD4B A1 A2 B1 C1 D1 VGND VGND VPWR VPWR X O2111AD4B
.ends O2111AD4

.subckt O2111AD4B A1 A2 B1 C1 D1 VGND VNB VPB VPWR X
X0 a_361_47# A2 VGND VNB abnmos
X1 a_361_47# A2 VGND VNB abnmos
X2 a_681_297# A1 VPWR VPB abpmos
X3 a_681_297# A1 VPWR VPB abpmos
X4 a_681_297# A1 VPWR VPB abpmos
X5 a_361_47# B1 a_445_47# VNB abnmos
X6 a_361_47# B1 a_445_47# VNB abnmos
X7 a_361_47# A2 VGND VNB abnmos
X8 a_361_47# A2 VGND VNB abnmos
X9 a_27_297# C1 VPWR VPB abpmos
X10 a_27_297# C1 VPWR VPB abpmos
X11 a_27_297# C1 VPWR VPB abpmos
X12 a_27_297# A2 a_681_297# VPB abpmos
X13 a_27_297# A2 a_681_297# VPB abpmos
X14 a_27_297# A2 a_681_297# VPB abpmos
X15 X a_27_297# VPWR VPB abpmos
X16 X a_27_297# VPWR VPB abpmos
X17 X a_27_297# VPWR VPB abpmos
X18 a_445_47# C1 a_27_47# VNB abnmos
X19 a_445_47# C1 a_27_47# VNB abnmos
X20 a_277_47# B1 a_361_47# VNB abnmos
X21 a_277_47# B1 a_361_47# VNB abnmos
X22 X a_27_297# VGND VNB abnmos
X23 X a_27_297# VGND VNB abnmos
X24 X a_27_297# VPWR VPB abpmos
X25 X a_27_297# VPWR VPB abpmos
X26 X a_27_297# VPWR VPB abpmos
X27 X a_27_297# VPWR VPB abpmos
X28 X a_27_297# VPWR VPB abpmos
X29 X a_27_297# VPWR VPB abpmos
X30 a_852_297# A1 VPWR VPB abpmos
X31 a_852_297# A1 VPWR VPB abpmos
X32 a_852_297# A1 VPWR VPB abpmos
X33 X a_27_297# VGND VNB abnmos
X34 X a_27_297# VGND VNB abnmos
X35 a_27_47# C1 a_277_47# VNB abnmos
X36 a_27_47# C1 a_277_47# VNB abnmos
X37 a_852_297# A2 a_27_297# VPB abpmos
X38 a_852_297# A2 a_27_297# VPB abpmos
X39 a_852_297# A2 a_27_297# VPB abpmos
X40 X a_27_297# VGND VNB abnmos
X41 X a_27_297# VGND VNB abnmos
X42 a_27_297# D1 a_27_47# VNB abnmos
X43 a_27_297# D1 a_27_47# VNB abnmos
X44 a_27_297# C1 VPWR VPB abpmos
X45 a_27_297# C1 VPWR VPB abpmos
X46 a_27_297# C1 VPWR VPB abpmos
X47 a_27_47# D1 a_27_297# VNB abnmos
X48 a_27_47# D1 a_27_297# VNB abnmos
X49 X a_27_297# VGND VNB abnmos
X50 X a_27_297# VGND VNB abnmos
X51 a_27_297# B1 VPWR VPB abpmos
X52 a_27_297# B1 VPWR VPB abpmos
X53 a_27_297# B1 VPWR VPB abpmos
X54 a_27_297# D1 VPWR VPB abpmos
X55 a_27_297# D1 VPWR VPB abpmos
X56 a_27_297# D1 VPWR VPB abpmos
X57 a_361_47# A1 VGND VNB abnmos
X58 a_361_47# A1 VGND VNB abnmos
X59 a_27_297# D1 VPWR VPB abpmos
X60 a_27_297# D1 VPWR VPB abpmos
X61 a_27_297# D1 VPWR VPB abpmos
X62 X a_27_297# VPWR VPB abpmos
X63 X a_27_297# VPWR VPB abpmos
X64 X a_27_297# VPWR VPB abpmos
X65 a_27_297# B1 VPWR VPB abpmos
X66 a_27_297# B1 VPWR VPB abpmos
X67 a_27_297# B1 VPWR VPB abpmos
X68 a_361_47# A1 VGND VNB abnmos
X69 a_361_47# A1 VGND VNB abnmos
.ends O2111AD4B
