* FAHCOND1 : abstract conversion of sky130_fd_sc_hd__fahcon_1
* 72 abstract devices (width -> parallel min-width fingers)
.subckt FAHCOND1 A B CI VGND VPWR COUT_N SUM
XFAHCOND1B A B CI VGND VGND VPWR VPWR COUT_N SUM FAHCOND1B
.ends FAHCOND1

.subckt FAHCOND1B A B CI VGND VNB VPB VPWR COUT_N SUM
X0 COUT_N a_726_47# a_1261_49# VPB abpmos
X1 COUT_N a_726_47# a_1261_49# VPB abpmos
X2 a_1144_49# B VPWR VPB abpmos
X3 a_1144_49# B VPWR VPB abpmos
X4 a_1144_49# B VPWR VPB abpmos
X5 a_1261_49# CI VPWR VPB abpmos
X6 a_1261_49# CI VPWR VPB abpmos
X7 a_1261_49# CI VPWR VPB abpmos
X8 a_28_47# a_67_199# VPWR VPB abpmos
X9 a_28_47# a_67_199# VPWR VPB abpmos
X10 a_28_47# a_67_199# VPWR VPB abpmos
X11 a_726_47# B a_67_199# VPB abpmos
X12 a_726_47# B a_67_199# VPB abpmos
X13 a_28_47# a_67_199# VGND VNB abnmos
X14 a_28_47# a_67_199# VGND VNB abnmos
X15 a_1710_49# a_434_49# a_1589_49# VPB abpmos
X16 a_1710_49# a_434_49# a_1589_49# VPB abpmos
X17 a_1261_49# a_434_49# COUT_N VNB abnmos
X18 a_1261_49# a_434_49# COUT_N VNB abnmos
X19 a_67_199# A VPWR VPB abpmos
X20 a_67_199# A VPWR VPB abpmos
X21 a_67_199# A VPWR VPB abpmos
X22 COUT_N a_726_47# a_1144_49# VNB abnmos
X23 COUT_N a_726_47# a_1144_49# VNB abnmos
X24 a_1589_49# CI VPWR VPB abpmos
X25 a_1589_49# CI VPWR VPB abpmos
X26 a_1589_49# CI VPWR VPB abpmos
X27 SUM a_1710_49# VPWR VPB abpmos
X28 SUM a_1710_49# VPWR VPB abpmos
X29 SUM a_1710_49# VPWR VPB abpmos
X30 a_434_49# a_488_21# a_67_199# VPB abpmos
X31 a_434_49# a_488_21# a_67_199# VPB abpmos
X32 a_1634_315# a_726_47# a_1710_49# VPB abpmos
X33 a_1634_315# a_726_47# a_1710_49# VPB abpmos
X34 a_726_47# B a_28_47# VNB abnmos
X35 a_726_47# B a_28_47# VNB abnmos
X36 a_488_21# B VGND VNB abnmos
X37 a_488_21# B VGND VNB abnmos
X38 a_1589_49# CI VGND VNB abnmos
X39 a_1589_49# CI VGND VNB abnmos
X40 a_1634_315# a_1589_49# VGND VNB abnmos
X41 a_1634_315# a_1589_49# VGND VNB abnmos
X42 a_1261_49# CI VGND VNB abnmos
X43 a_1261_49# CI VGND VNB abnmos
X44 a_67_199# B a_434_49# VNB abnmos
X45 a_67_199# B a_434_49# VNB abnmos
X46 a_1710_49# a_434_49# a_1634_315# VNB abnmos
X47 a_1710_49# a_434_49# a_1634_315# VNB abnmos
X48 a_1144_49# a_434_49# COUT_N VPB abpmos
X49 a_1144_49# a_434_49# COUT_N VPB abpmos
X50 a_67_199# a_488_21# a_726_47# VNB abnmos
X51 a_67_199# a_488_21# a_726_47# VNB abnmos
X52 a_1144_49# B VGND VNB abnmos
X53 a_1144_49# B VGND VNB abnmos
X54 SUM a_1710_49# VGND VNB abnmos
X55 SUM a_1710_49# VGND VNB abnmos
X56 a_28_47# a_488_21# a_726_47# VPB abpmos
X57 a_28_47# a_488_21# a_726_47# VPB abpmos
X58 a_488_21# B VPWR VPB abpmos
X59 a_488_21# B VPWR VPB abpmos
X60 a_488_21# B VPWR VPB abpmos
X61 a_434_49# a_488_21# a_28_47# VNB abnmos
X62 a_434_49# a_488_21# a_28_47# VNB abnmos
X63 a_1589_49# a_726_47# a_1710_49# VNB abnmos
X64 a_1589_49# a_726_47# a_1710_49# VNB abnmos
X65 a_67_199# A VGND VNB abnmos
X66 a_67_199# A VGND VNB abnmos
X67 a_28_47# B a_434_49# VPB abpmos
X68 a_28_47# B a_434_49# VPB abpmos
X69 a_1634_315# a_1589_49# VPWR VPB abpmos
X70 a_1634_315# a_1589_49# VPWR VPB abpmos
X71 a_1634_315# a_1589_49# VPWR VPB abpmos
.ends FAHCOND1B
