* A211OID4 : abstract conversion of sky130_fd_sc_hd__a211oi_4
* 80 abstract devices (width -> parallel min-width fingers)
.subckt A211OID4 A1 A2 B1 C1 VGND VPWR Y
XA211OID4B A1 A2 B1 C1 VGND VGND VPWR VPWR Y A211OID4B
.ends A211OID4

.subckt A211OID4B A1 A2 B1 C1 VGND VNB VPB VPWR Y
X0 Y C1 a_781_297# VPB abpmos
X1 Y C1 a_781_297# VPB abpmos
X2 Y C1 a_781_297# VPB abpmos
X3 Y A1 a_109_47# VNB abnmos
X4 Y A1 a_109_47# VNB abnmos
X5 Y A1 a_109_47# VNB abnmos
X6 Y A1 a_109_47# VNB abnmos
X7 Y C1 VGND VNB abnmos
X8 Y C1 VGND VNB abnmos
X9 a_27_297# B1 a_949_297# VPB abpmos
X10 a_27_297# B1 a_949_297# VPB abpmos
X11 a_27_297# B1 a_949_297# VPB abpmos
X12 Y C1 VGND VNB abnmos
X13 Y C1 VGND VNB abnmos
X14 a_27_297# A1 VPWR VPB abpmos
X15 a_27_297# A1 VPWR VPB abpmos
X16 a_27_297# A1 VPWR VPB abpmos
X17 a_27_297# A2 VPWR VPB abpmos
X18 a_27_297# A2 VPWR VPB abpmos
X19 a_27_297# A2 VPWR VPB abpmos
X20 a_109_47# A1 Y VNB abnmos
X21 a_109_47# A1 Y VNB abnmos
X22 a_781_297# B1 a_27_297# VPB abpmos
X23 a_781_297# B1 a_27_297# VPB abpmos
X24 a_781_297# B1 a_27_297# VPB abpmos
X25 a_949_297# C1 Y VPB abpmos
X26 a_949_297# C1 Y VPB abpmos
X27 a_949_297# C1 Y VPB abpmos
X28 a_781_297# C1 Y VPB abpmos
X29 a_781_297# C1 Y VPB abpmos
X30 a_781_297# C1 Y VPB abpmos
X31 a_1301_297# B1 a_27_297# VPB abpmos
X32 a_1301_297# B1 a_27_297# VPB abpmos
X33 a_1301_297# B1 a_27_297# VPB abpmos
X34 Y B1 VGND VNB abnmos
X35 Y B1 VGND VNB abnmos
X36 a_27_297# A1 VPWR VPB abpmos
X37 a_27_297# A1 VPWR VPB abpmos
X38 a_27_297# A1 VPWR VPB abpmos
X39 a_27_297# B1 a_781_297# VPB abpmos
X40 a_27_297# B1 a_781_297# VPB abpmos
X41 a_27_297# B1 a_781_297# VPB abpmos
X42 a_109_47# A1 Y VNB abnmos
X43 a_109_47# A1 Y VNB abnmos
X44 Y B1 VGND VNB abnmos
X45 Y B1 VGND VNB abnmos
X46 Y B1 VGND VNB abnmos
X47 Y B1 VGND VNB abnmos
X48 Y C1 VGND VNB abnmos
X49 Y C1 VGND VNB abnmos
X50 Y C1 VGND VNB abnmos
X51 Y C1 VGND VNB abnmos
X52 Y B1 VGND VNB abnmos
X53 Y B1 VGND VNB abnmos
X54 a_109_47# A2 VGND VNB abnmos
X55 a_109_47# A2 VGND VNB abnmos
X56 a_109_47# A2 VGND VNB abnmos
X57 a_109_47# A2 VGND VNB abnmos
X58 a_27_297# A2 VPWR VPB abpmos
X59 a_27_297# A2 VPWR VPB abpmos
X60 a_27_297# A2 VPWR VPB abpmos
X61 Y C1 a_1301_297# VPB abpmos
X62 Y C1 a_1301_297# VPB abpmos
X63 Y C1 a_1301_297# VPB abpmos
X64 a_109_47# A2 VGND VNB abnmos
X65 a_109_47# A2 VGND VNB abnmos
X66 a_27_297# A1 VPWR VPB abpmos
X67 a_27_297# A1 VPWR VPB abpmos
X68 a_27_297# A1 VPWR VPB abpmos
X69 a_27_297# A2 VPWR VPB abpmos
X70 a_27_297# A2 VPWR VPB abpmos
X71 a_27_297# A2 VPWR VPB abpmos
X72 a_27_297# A2 VPWR VPB abpmos
X73 a_27_297# A2 VPWR VPB abpmos
X74 a_27_297# A2 VPWR VPB abpmos
X75 a_109_47# A2 VGND VNB abnmos
X76 a_109_47# A2 VGND VNB abnmos
X77 a_27_297# A1 VPWR VPB abpmos
X78 a_27_297# A1 VPWR VPB abpmos
X79 a_27_297# A1 VPWR VPB abpmos
.ends A211OID4B
