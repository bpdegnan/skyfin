* A2BB2OD1 : abstract conversion of sky130_fd_sc_hd__a2bb2o_1
* 15 abstract devices (width -> parallel min-width fingers)
.subckt A2BB2OD1 A1_N A2_N B1 B2 VGND VPWR X
XA2BB2OD1B A1_N A2_N B1 B2 VGND VGND VPWR VPWR X A2BB2OD1B
.ends A2BB2OD1

.subckt A2BB2OD1B A1_N A2_N B1 B2 VGND VNB VPB VPWR X
X0 a_489_413# B2 VPWR VPB abpmos
X1 a_226_47# A1_N VGND VNB abnmos
X2 a_76_199# B2 a_556_47# VNB abnmos
X3 a_226_297# A1_N VPWR VPB abpmos
X4 a_226_297# A2_N a_226_47# VPB abpmos
X5 a_76_199# a_226_47# VGND VNB abnmos
X6 X a_76_199# VGND VNB abnmos
X7 X a_76_199# VGND VNB abnmos
X8 X a_76_199# VPWR VPB abpmos
X9 X a_76_199# VPWR VPB abpmos
X10 X a_76_199# VPWR VPB abpmos
X11 a_76_199# a_226_47# a_489_413# VPB abpmos
X12 a_226_47# A2_N VGND VNB abnmos
X13 a_489_413# B1 VPWR VPB abpmos
X14 a_556_47# B1 VGND VNB abnmos
.ends A2BB2OD1B
