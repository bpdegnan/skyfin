* OR4D4 : abstract conversion of sky130_fd_sc_hd__or4_4
* 40 abstract devices (width -> parallel min-width fingers)
.subckt OR4D4 A B C D VGND VPWR X
XOR4D4B A B C D VGND VGND VPWR VPWR X OR4D4B
.ends OR4D4

.subckt OR4D4B A B C D VGND VNB VPB VPWR X
X0 a_32_297# C VGND VNB abnmos
X1 a_32_297# C VGND VNB abnmos
X2 a_114_297# C a_220_297# VPB abpmos
X3 a_114_297# C a_220_297# VPB abpmos
X4 a_114_297# C a_220_297# VPB abpmos
X5 a_32_297# D VGND VNB abnmos
X6 a_32_297# D VGND VNB abnmos
X7 X a_32_297# VGND VNB abnmos
X8 X a_32_297# VGND VNB abnmos
X9 a_32_297# D a_114_297# VPB abpmos
X10 a_32_297# D a_114_297# VPB abpmos
X11 a_32_297# D a_114_297# VPB abpmos
X12 X a_32_297# VGND VNB abnmos
X13 X a_32_297# VGND VNB abnmos
X14 X a_32_297# VPWR VPB abpmos
X15 X a_32_297# VPWR VPB abpmos
X16 X a_32_297# VPWR VPB abpmos
X17 X a_32_297# VPWR VPB abpmos
X18 X a_32_297# VPWR VPB abpmos
X19 X a_32_297# VPWR VPB abpmos
X20 X a_32_297# VPWR VPB abpmos
X21 X a_32_297# VPWR VPB abpmos
X22 X a_32_297# VPWR VPB abpmos
X23 X a_32_297# VPWR VPB abpmos
X24 X a_32_297# VPWR VPB abpmos
X25 X a_32_297# VPWR VPB abpmos
X26 a_32_297# A VGND VNB abnmos
X27 a_32_297# A VGND VNB abnmos
X28 a_304_297# A VPWR VPB abpmos
X29 a_304_297# A VPWR VPB abpmos
X30 a_304_297# A VPWR VPB abpmos
X31 X a_32_297# VGND VNB abnmos
X32 X a_32_297# VGND VNB abnmos
X33 a_32_297# B VGND VNB abnmos
X34 a_32_297# B VGND VNB abnmos
X35 a_220_297# B a_304_297# VPB abpmos
X36 a_220_297# B a_304_297# VPB abpmos
X37 a_220_297# B a_304_297# VPB abpmos
X38 X a_32_297# VGND VNB abnmos
X39 X a_32_297# VGND VNB abnmos
.ends OR4D4B
