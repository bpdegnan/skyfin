* NAND3BD2 : abstract conversion of sky130_fd_sc_hd__nand3b_2
* 32 abstract devices (width -> parallel min-width fingers)
.subckt NAND3BD2 A_N B C VGND VPWR Y
XNAND3BD2B A_N B C VGND VGND VPWR VPWR Y NAND3BD2B
.ends NAND3BD2

.subckt NAND3BD2B A_N B C VGND VNB VPB VPWR Y
X0 Y a_27_47# VPWR VPB abpmos
X1 Y a_27_47# VPWR VPB abpmos
X2 Y a_27_47# VPWR VPB abpmos
X3 Y a_27_47# VPWR VPB abpmos
X4 Y a_27_47# VPWR VPB abpmos
X5 Y a_27_47# VPWR VPB abpmos
X6 a_408_47# a_27_47# Y VNB abnmos
X7 a_408_47# a_27_47# Y VNB abnmos
X8 a_218_47# B a_408_47# VNB abnmos
X9 a_218_47# B a_408_47# VNB abnmos
X10 a_218_47# C VGND VNB abnmos
X11 a_218_47# C VGND VNB abnmos
X12 a_27_47# A_N VPWR VPB abpmos
X13 a_408_47# B a_218_47# VNB abnmos
X14 a_408_47# B a_218_47# VNB abnmos
X15 Y C VPWR VPB abpmos
X16 Y C VPWR VPB abpmos
X17 Y C VPWR VPB abpmos
X18 Y B VPWR VPB abpmos
X19 Y B VPWR VPB abpmos
X20 Y B VPWR VPB abpmos
X21 a_27_47# A_N VGND VNB abnmos
X22 Y C VPWR VPB abpmos
X23 Y C VPWR VPB abpmos
X24 Y C VPWR VPB abpmos
X25 a_218_47# C VGND VNB abnmos
X26 a_218_47# C VGND VNB abnmos
X27 Y B VPWR VPB abpmos
X28 Y B VPWR VPB abpmos
X29 Y B VPWR VPB abpmos
X30 Y a_27_47# a_408_47# VNB abnmos
X31 Y a_27_47# a_408_47# VNB abnmos
.ends NAND3BD2B
