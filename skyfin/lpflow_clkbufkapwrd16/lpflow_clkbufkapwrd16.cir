* LPFLOW_CLKBUFKAPWRD16 : abstract conversion of sky130_fd_sc_hd__lpflow_clkbufkapwr_16
* 80 abstract devices (width -> parallel min-width fingers) ; secondary power ['KAPWR'] collapsed onto VPWR
.subckt LPFLOW_CLKBUFKAPWRD16 A VGND VPWR X
XLPFLOW_CLKBUFKAPWRD16B A VPWR VGND VGND VPWR VPWR X LPFLOW_CLKBUFKAPWRD16B
.ends LPFLOW_CLKBUFKAPWRD16

.subckt LPFLOW_CLKBUFKAPWRD16B A KAPWR VGND VNB VPB VPWR X
X0 KAPWR a_110_47# X VPB abpmos
X1 KAPWR a_110_47# X VPB abpmos
X2 KAPWR a_110_47# X VPB abpmos
X3 X a_110_47# VGND VNB abnmos
X4 X a_110_47# VGND VNB abnmos
X5 a_110_47# A KAPWR VPB abpmos
X6 a_110_47# A KAPWR VPB abpmos
X7 a_110_47# A KAPWR VPB abpmos
X8 KAPWR a_110_47# X VPB abpmos
X9 KAPWR a_110_47# X VPB abpmos
X10 KAPWR a_110_47# X VPB abpmos
X11 X a_110_47# KAPWR VPB abpmos
X12 X a_110_47# KAPWR VPB abpmos
X13 X a_110_47# KAPWR VPB abpmos
X14 a_110_47# A VGND VNB abnmos
X15 KAPWR A a_110_47# VPB abpmos
X16 KAPWR A a_110_47# VPB abpmos
X17 KAPWR A a_110_47# VPB abpmos
X18 X a_110_47# VGND VNB abnmos
X19 a_110_47# A VGND VNB abnmos
X20 X a_110_47# VGND VNB abnmos
X21 X a_110_47# VGND VNB abnmos
X22 a_110_47# A KAPWR VPB abpmos
X23 a_110_47# A KAPWR VPB abpmos
X24 a_110_47# A KAPWR VPB abpmos
X25 KAPWR a_110_47# X VPB abpmos
X26 KAPWR a_110_47# X VPB abpmos
X27 KAPWR a_110_47# X VPB abpmos
X28 X a_110_47# VGND VNB abnmos
X29 KAPWR A a_110_47# VPB abpmos
X30 KAPWR A a_110_47# VPB abpmos
X31 KAPWR A a_110_47# VPB abpmos
X32 X a_110_47# VGND VNB abnmos
X33 X a_110_47# VGND VNB abnmos
X34 X a_110_47# VGND VNB abnmos
X35 X a_110_47# VGND VNB abnmos
X36 X a_110_47# KAPWR VPB abpmos
X37 X a_110_47# KAPWR VPB abpmos
X38 X a_110_47# KAPWR VPB abpmos
X39 X a_110_47# KAPWR VPB abpmos
X40 X a_110_47# KAPWR VPB abpmos
X41 X a_110_47# KAPWR VPB abpmos
X42 X a_110_47# KAPWR VPB abpmos
X43 X a_110_47# KAPWR VPB abpmos
X44 X a_110_47# KAPWR VPB abpmos
X45 KAPWR a_110_47# X VPB abpmos
X46 KAPWR a_110_47# X VPB abpmos
X47 KAPWR a_110_47# X VPB abpmos
X48 KAPWR a_110_47# X VPB abpmos
X49 KAPWR a_110_47# X VPB abpmos
X50 KAPWR a_110_47# X VPB abpmos
X51 X a_110_47# VGND VNB abnmos
X52 X a_110_47# KAPWR VPB abpmos
X53 X a_110_47# KAPWR VPB abpmos
X54 X a_110_47# KAPWR VPB abpmos
X55 X a_110_47# VGND VNB abnmos
X56 KAPWR a_110_47# X VPB abpmos
X57 KAPWR a_110_47# X VPB abpmos
X58 KAPWR a_110_47# X VPB abpmos
X59 X a_110_47# VGND VNB abnmos
X60 X a_110_47# VGND VNB abnmos
X61 X a_110_47# KAPWR VPB abpmos
X62 X a_110_47# KAPWR VPB abpmos
X63 X a_110_47# KAPWR VPB abpmos
X64 X a_110_47# KAPWR VPB abpmos
X65 X a_110_47# KAPWR VPB abpmos
X66 X a_110_47# KAPWR VPB abpmos
X67 X a_110_47# KAPWR VPB abpmos
X68 X a_110_47# KAPWR VPB abpmos
X69 X a_110_47# KAPWR VPB abpmos
X70 a_110_47# A VGND VNB abnmos
X71 KAPWR a_110_47# X VPB abpmos
X72 KAPWR a_110_47# X VPB abpmos
X73 KAPWR a_110_47# X VPB abpmos
X74 a_110_47# A VGND VNB abnmos
X75 KAPWR a_110_47# X VPB abpmos
X76 KAPWR a_110_47# X VPB abpmos
X77 KAPWR a_110_47# X VPB abpmos
X78 X a_110_47# VGND VNB abnmos
X79 X a_110_47# VGND VNB abnmos
.ends LPFLOW_CLKBUFKAPWRD16B
