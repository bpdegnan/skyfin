* A2111OID4 : abstract conversion of sky130_fd_sc_hd__a2111oi_4
* 100 abstract devices (width -> parallel min-width fingers)
.subckt A2111OID4 A1 A2 B1 C1 D1 VGND VPWR Y
XA2111OID4B A1 A2 B1 C1 D1 VGND VGND VPWR VPWR Y A2111OID4B
.ends A2111OID4

.subckt A2111OID4B A1 A2 B1 C1 D1 VGND VNB VPB VPWR Y
X0 a_821_297# A1 VPWR VPB abpmos
X1 a_821_297# A1 VPWR VPB abpmos
X2 a_821_297# A1 VPWR VPB abpmos
X3 a_821_297# A2 VPWR VPB abpmos
X4 a_821_297# A2 VPWR VPB abpmos
X5 a_821_297# A2 VPWR VPB abpmos
X6 Y C1 VGND VNB abnmos
X7 Y C1 VGND VNB abnmos
X8 Y D1 a_28_297# VPB abpmos
X9 Y D1 a_28_297# VPB abpmos
X10 Y D1 a_28_297# VPB abpmos
X11 Y B1 VGND VNB abnmos
X12 Y B1 VGND VNB abnmos
X13 a_821_297# B1 a_455_297# VPB abpmos
X14 a_821_297# B1 a_455_297# VPB abpmos
X15 a_821_297# B1 a_455_297# VPB abpmos
X16 a_28_297# D1 Y VPB abpmos
X17 a_28_297# D1 Y VPB abpmos
X18 a_28_297# D1 Y VPB abpmos
X19 a_455_297# B1 a_821_297# VPB abpmos
X20 a_455_297# B1 a_821_297# VPB abpmos
X21 a_455_297# B1 a_821_297# VPB abpmos
X22 a_821_297# B1 a_455_297# VPB abpmos
X23 a_821_297# B1 a_455_297# VPB abpmos
X24 a_821_297# B1 a_455_297# VPB abpmos
X25 a_1205_47# A1 Y VNB abnmos
X26 a_1205_47# A1 Y VNB abnmos
X27 Y D1 a_28_297# VPB abpmos
X28 Y D1 a_28_297# VPB abpmos
X29 Y D1 a_28_297# VPB abpmos
X30 a_28_297# C1 a_455_297# VPB abpmos
X31 a_28_297# C1 a_455_297# VPB abpmos
X32 a_28_297# C1 a_455_297# VPB abpmos
X33 a_28_297# D1 Y VPB abpmos
X34 a_28_297# D1 Y VPB abpmos
X35 a_28_297# D1 Y VPB abpmos
X36 Y D1 VGND VNB abnmos
X37 Y D1 VGND VNB abnmos
X38 Y B1 VGND VNB abnmos
X39 Y B1 VGND VNB abnmos
X40 a_455_297# B1 a_821_297# VPB abpmos
X41 a_455_297# B1 a_821_297# VPB abpmos
X42 a_455_297# B1 a_821_297# VPB abpmos
X43 a_821_297# A1 VPWR VPB abpmos
X44 a_821_297# A1 VPWR VPB abpmos
X45 a_821_297# A1 VPWR VPB abpmos
X46 a_821_297# A1 VPWR VPB abpmos
X47 a_821_297# A1 VPWR VPB abpmos
X48 a_821_297# A1 VPWR VPB abpmos
X49 Y D1 VGND VNB abnmos
X50 Y D1 VGND VNB abnmos
X51 a_28_297# C1 a_455_297# VPB abpmos
X52 a_28_297# C1 a_455_297# VPB abpmos
X53 a_28_297# C1 a_455_297# VPB abpmos
X54 a_455_297# C1 a_28_297# VPB abpmos
X55 a_455_297# C1 a_28_297# VPB abpmos
X56 a_455_297# C1 a_28_297# VPB abpmos
X57 Y D1 VGND VNB abnmos
X58 Y D1 VGND VNB abnmos
X59 Y A1 a_1205_47# VNB abnmos
X60 Y A1 a_1205_47# VNB abnmos
X61 a_1205_47# A1 Y VNB abnmos
X62 a_1205_47# A1 Y VNB abnmos
X63 a_1205_47# A2 VGND VNB abnmos
X64 a_1205_47# A2 VGND VNB abnmos
X65 a_821_297# A2 VPWR VPB abpmos
X66 a_821_297# A2 VPWR VPB abpmos
X67 a_821_297# A2 VPWR VPB abpmos
X68 a_821_297# A2 VPWR VPB abpmos
X69 a_821_297# A2 VPWR VPB abpmos
X70 a_821_297# A2 VPWR VPB abpmos
X71 a_1205_47# A2 VGND VNB abnmos
X72 a_1205_47# A2 VGND VNB abnmos
X73 Y C1 VGND VNB abnmos
X74 Y C1 VGND VNB abnmos
X75 Y C1 VGND VNB abnmos
X76 Y C1 VGND VNB abnmos
X77 Y B1 VGND VNB abnmos
X78 Y B1 VGND VNB abnmos
X79 a_821_297# A1 VPWR VPB abpmos
X80 a_821_297# A1 VPWR VPB abpmos
X81 a_821_297# A1 VPWR VPB abpmos
X82 a_455_297# C1 a_28_297# VPB abpmos
X83 a_455_297# C1 a_28_297# VPB abpmos
X84 a_455_297# C1 a_28_297# VPB abpmos
X85 Y D1 VGND VNB abnmos
X86 Y D1 VGND VNB abnmos
X87 Y B1 VGND VNB abnmos
X88 Y B1 VGND VNB abnmos
X89 a_1205_47# A2 VGND VNB abnmos
X90 a_1205_47# A2 VGND VNB abnmos
X91 Y A1 a_1205_47# VNB abnmos
X92 Y A1 a_1205_47# VNB abnmos
X93 a_1205_47# A2 VGND VNB abnmos
X94 a_1205_47# A2 VGND VNB abnmos
X95 a_821_297# A2 VPWR VPB abpmos
X96 a_821_297# A2 VPWR VPB abpmos
X97 a_821_297# A2 VPWR VPB abpmos
X98 Y C1 VGND VNB abnmos
X99 Y C1 VGND VNB abnmos
.ends A2111OID4B
