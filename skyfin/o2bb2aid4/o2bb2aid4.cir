* O2BB2AID4 : abstract conversion of sky130_fd_sc_hd__o2bb2ai_4
* 100 abstract devices (width -> parallel min-width fingers)
.subckt O2BB2AID4 A1_N A2_N B1 B2 VGND VPWR Y
XO2BB2AID4B A1_N A2_N B1 B2 VGND VGND VPWR VPWR Y O2BB2AID4B
.ends O2BB2AID4

.subckt O2BB2AID4B A1_N A2_N B1 B2 VGND VNB VPB VPWR Y
X0 a_113_47# A1_N VPWR VPB abpmos
X1 a_113_47# A1_N VPWR VPB abpmos
X2 a_113_47# A1_N VPWR VPB abpmos
X3 a_807_47# B2 VGND VNB abnmos
X4 a_807_47# B2 VGND VNB abnmos
X5 a_807_47# B1 VGND VNB abnmos
X6 a_807_47# B1 VGND VNB abnmos
X7 a_113_47# A2_N a_27_47# VNB abnmos
X8 a_113_47# A2_N a_27_47# VNB abnmos
X9 a_113_47# A2_N VPWR VPB abpmos
X10 a_113_47# A2_N VPWR VPB abpmos
X11 a_113_47# A2_N VPWR VPB abpmos
X12 a_113_47# A2_N VPWR VPB abpmos
X13 a_113_47# A2_N VPWR VPB abpmos
X14 a_113_47# A2_N VPWR VPB abpmos
X15 a_807_47# B2 VGND VNB abnmos
X16 a_807_47# B2 VGND VNB abnmos
X17 a_113_47# A1_N VPWR VPB abpmos
X18 a_113_47# A1_N VPWR VPB abpmos
X19 a_113_47# A1_N VPWR VPB abpmos
X20 a_27_47# A2_N a_113_47# VNB abnmos
X21 a_27_47# A2_N a_113_47# VNB abnmos
X22 a_1241_297# B1 VPWR VPB abpmos
X23 a_1241_297# B1 VPWR VPB abpmos
X24 a_1241_297# B1 VPWR VPB abpmos
X25 a_113_47# A2_N VPWR VPB abpmos
X26 a_113_47# A2_N VPWR VPB abpmos
X27 a_113_47# A2_N VPWR VPB abpmos
X28 Y B2 a_1241_297# VPB abpmos
X29 Y B2 a_1241_297# VPB abpmos
X30 Y B2 a_1241_297# VPB abpmos
X31 a_113_47# A2_N VPWR VPB abpmos
X32 a_113_47# A2_N VPWR VPB abpmos
X33 a_113_47# A2_N VPWR VPB abpmos
X34 Y a_113_47# VPWR VPB abpmos
X35 Y a_113_47# VPWR VPB abpmos
X36 Y a_113_47# VPWR VPB abpmos
X37 Y B2 a_1241_297# VPB abpmos
X38 Y B2 a_1241_297# VPB abpmos
X39 Y B2 a_1241_297# VPB abpmos
X40 a_807_47# B1 VGND VNB abnmos
X41 a_807_47# B1 VGND VNB abnmos
X42 a_27_47# A2_N a_113_47# VNB abnmos
X43 a_27_47# A2_N a_113_47# VNB abnmos
X44 a_807_47# B1 VGND VNB abnmos
X45 a_807_47# B1 VGND VNB abnmos
X46 a_1241_297# B1 VPWR VPB abpmos
X47 a_1241_297# B1 VPWR VPB abpmos
X48 a_1241_297# B1 VPWR VPB abpmos
X49 a_1241_297# B2 Y VPB abpmos
X50 a_1241_297# B2 Y VPB abpmos
X51 a_1241_297# B2 Y VPB abpmos
X52 Y a_113_47# VPWR VPB abpmos
X53 Y a_113_47# VPWR VPB abpmos
X54 Y a_113_47# VPWR VPB abpmos
X55 a_1241_297# B2 Y VPB abpmos
X56 a_1241_297# B2 Y VPB abpmos
X57 a_1241_297# B2 Y VPB abpmos
X58 a_27_47# A1_N VGND VNB abnmos
X59 a_27_47# A1_N VGND VNB abnmos
X60 Y a_113_47# a_807_47# VNB abnmos
X61 Y a_113_47# a_807_47# VNB abnmos
X62 a_807_47# B2 VGND VNB abnmos
X63 a_807_47# B2 VGND VNB abnmos
X64 a_113_47# A1_N VPWR VPB abpmos
X65 a_113_47# A1_N VPWR VPB abpmos
X66 a_113_47# A1_N VPWR VPB abpmos
X67 a_113_47# A2_N a_27_47# VNB abnmos
X68 a_113_47# A2_N a_27_47# VNB abnmos
X69 a_27_47# A1_N VGND VNB abnmos
X70 a_27_47# A1_N VGND VNB abnmos
X71 Y a_113_47# a_807_47# VNB abnmos
X72 Y a_113_47# a_807_47# VNB abnmos
X73 Y a_113_47# VPWR VPB abpmos
X74 Y a_113_47# VPWR VPB abpmos
X75 Y a_113_47# VPWR VPB abpmos
X76 a_807_47# B2 VGND VNB abnmos
X77 a_807_47# B2 VGND VNB abnmos
X78 a_113_47# A1_N VPWR VPB abpmos
X79 a_113_47# A1_N VPWR VPB abpmos
X80 a_113_47# A1_N VPWR VPB abpmos
X81 Y a_113_47# VPWR VPB abpmos
X82 Y a_113_47# VPWR VPB abpmos
X83 Y a_113_47# VPWR VPB abpmos
X84 a_1241_297# B1 VPWR VPB abpmos
X85 a_1241_297# B1 VPWR VPB abpmos
X86 a_1241_297# B1 VPWR VPB abpmos
X87 a_27_47# A1_N VGND VNB abnmos
X88 a_27_47# A1_N VGND VNB abnmos
X89 a_807_47# a_113_47# Y VNB abnmos
X90 a_807_47# a_113_47# Y VNB abnmos
X91 a_1241_297# B1 VPWR VPB abpmos
X92 a_1241_297# B1 VPWR VPB abpmos
X93 a_1241_297# B1 VPWR VPB abpmos
X94 a_27_47# A1_N VGND VNB abnmos
X95 a_27_47# A1_N VGND VNB abnmos
X96 a_807_47# a_113_47# Y VNB abnmos
X97 a_807_47# a_113_47# Y VNB abnmos
X98 a_807_47# B1 VGND VNB abnmos
X99 a_807_47# B1 VGND VNB abnmos
.ends O2BB2AID4B
