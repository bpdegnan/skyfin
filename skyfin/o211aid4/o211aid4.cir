* O211AID4 : abstract conversion of sky130_fd_sc_hd__o211ai_4
* 80 abstract devices (width -> parallel min-width fingers)
.subckt O211AID4 A1 A2 B1 C1 VGND VPWR Y
XO211AID4B A1 A2 B1 C1 VGND VGND VPWR VPWR Y O211AID4B
.ends O211AID4

.subckt O211AID4B A1 A2 B1 C1 VGND VNB VPB VPWR Y
X0 a_27_47# B1 a_978_47# VNB abnmos
X1 a_27_47# B1 a_978_47# VNB abnmos
X2 Y C1 a_1314_47# VNB abnmos
X3 Y C1 a_1314_47# VNB abnmos
X4 a_110_297# A1 VPWR VPB abpmos
X5 a_110_297# A1 VPWR VPB abpmos
X6 a_110_297# A1 VPWR VPB abpmos
X7 Y C1 a_806_47# VNB abnmos
X8 Y C1 a_806_47# VNB abnmos
X9 a_27_47# A2 VGND VNB abnmos
X10 a_27_47# A2 VGND VNB abnmos
X11 Y B1 VPWR VPB abpmos
X12 Y B1 VPWR VPB abpmos
X13 Y B1 VPWR VPB abpmos
X14 Y C1 VPWR VPB abpmos
X15 Y C1 VPWR VPB abpmos
X16 Y C1 VPWR VPB abpmos
X17 a_110_297# A1 VPWR VPB abpmos
X18 a_110_297# A1 VPWR VPB abpmos
X19 a_110_297# A1 VPWR VPB abpmos
X20 a_27_47# A2 VGND VNB abnmos
X21 a_27_47# A2 VGND VNB abnmos
X22 a_978_47# C1 Y VNB abnmos
X23 a_978_47# C1 Y VNB abnmos
X24 a_27_47# A1 VGND VNB abnmos
X25 a_27_47# A1 VGND VNB abnmos
X26 a_27_47# A2 VGND VNB abnmos
X27 a_27_47# A2 VGND VNB abnmos
X28 a_110_297# A2 Y VPB abpmos
X29 a_110_297# A2 Y VPB abpmos
X30 a_110_297# A2 Y VPB abpmos
X31 Y A2 a_110_297# VPB abpmos
X32 Y A2 a_110_297# VPB abpmos
X33 Y A2 a_110_297# VPB abpmos
X34 a_110_297# A1 VPWR VPB abpmos
X35 a_110_297# A1 VPWR VPB abpmos
X36 a_110_297# A1 VPWR VPB abpmos
X37 Y C1 VPWR VPB abpmos
X38 Y C1 VPWR VPB abpmos
X39 Y C1 VPWR VPB abpmos
X40 Y C1 VPWR VPB abpmos
X41 Y C1 VPWR VPB abpmos
X42 Y C1 VPWR VPB abpmos
X43 Y B1 VPWR VPB abpmos
X44 Y B1 VPWR VPB abpmos
X45 Y B1 VPWR VPB abpmos
X46 a_27_47# A1 VGND VNB abnmos
X47 a_27_47# A1 VGND VNB abnmos
X48 Y B1 VPWR VPB abpmos
X49 Y B1 VPWR VPB abpmos
X50 Y B1 VPWR VPB abpmos
X51 a_110_297# A1 VPWR VPB abpmos
X52 a_110_297# A1 VPWR VPB abpmos
X53 a_110_297# A1 VPWR VPB abpmos
X54 Y A2 a_110_297# VPB abpmos
X55 Y A2 a_110_297# VPB abpmos
X56 Y A2 a_110_297# VPB abpmos
X57 Y B1 VPWR VPB abpmos
X58 Y B1 VPWR VPB abpmos
X59 Y B1 VPWR VPB abpmos
X60 a_27_47# B1 a_806_47# VNB abnmos
X61 a_27_47# B1 a_806_47# VNB abnmos
X62 Y C1 VPWR VPB abpmos
X63 Y C1 VPWR VPB abpmos
X64 Y C1 VPWR VPB abpmos
X65 a_806_47# C1 Y VNB abnmos
X66 a_806_47# C1 Y VNB abnmos
X67 a_1314_47# B1 a_27_47# VNB abnmos
X68 a_1314_47# B1 a_27_47# VNB abnmos
X69 a_806_47# B1 a_27_47# VNB abnmos
X70 a_806_47# B1 a_27_47# VNB abnmos
X71 a_110_297# A2 Y VPB abpmos
X72 a_110_297# A2 Y VPB abpmos
X73 a_110_297# A2 Y VPB abpmos
X74 a_27_47# A1 VGND VNB abnmos
X75 a_27_47# A1 VGND VNB abnmos
X76 a_27_47# A1 VGND VNB abnmos
X77 a_27_47# A1 VGND VNB abnmos
X78 a_27_47# A2 VGND VNB abnmos
X79 a_27_47# A2 VGND VNB abnmos
.ends O211AID4B
