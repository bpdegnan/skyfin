* LPFLOW_ISOBUFSRCD8 : abstract conversion of sky130_fd_sc_hd__lpflow_isobufsrc_8
* 90 abstract devices (width -> parallel min-width fingers)
.subckt LPFLOW_ISOBUFSRCD8 A SLEEP VGND VPWR X
XLPFLOW_ISOBUFSRCD8B A SLEEP VGND VGND VPWR VPWR X LPFLOW_ISOBUFSRCD8B
.ends LPFLOW_ISOBUFSRCD8

.subckt LPFLOW_ISOBUFSRCD8B A SLEEP VGND VNB VPB VPWR X
X0 a_321_297# SLEEP X VPB abpmos
X1 a_321_297# SLEEP X VPB abpmos
X2 a_321_297# SLEEP X VPB abpmos
X3 X a_123_297# VGND VNB abnmos
X4 X a_123_297# VGND VNB abnmos
X5 X a_123_297# VGND VNB abnmos
X6 X a_123_297# VGND VNB abnmos
X7 X SLEEP VGND VNB abnmos
X8 X SLEEP VGND VNB abnmos
X9 a_123_297# A VPWR VPB abpmos
X10 a_123_297# A VPWR VPB abpmos
X11 a_123_297# A VPWR VPB abpmos
X12 X a_123_297# VGND VNB abnmos
X13 X a_123_297# VGND VNB abnmos
X14 a_321_297# a_123_297# VPWR VPB abpmos
X15 a_321_297# a_123_297# VPWR VPB abpmos
X16 a_321_297# a_123_297# VPWR VPB abpmos
X17 X SLEEP VGND VNB abnmos
X18 X SLEEP VGND VNB abnmos
X19 a_321_297# a_123_297# VPWR VPB abpmos
X20 a_321_297# a_123_297# VPWR VPB abpmos
X21 a_321_297# a_123_297# VPWR VPB abpmos
X22 X a_123_297# VGND VNB abnmos
X23 X a_123_297# VGND VNB abnmos
X24 a_321_297# a_123_297# VPWR VPB abpmos
X25 a_321_297# a_123_297# VPWR VPB abpmos
X26 a_321_297# a_123_297# VPWR VPB abpmos
X27 a_321_297# a_123_297# VPWR VPB abpmos
X28 a_321_297# a_123_297# VPWR VPB abpmos
X29 a_321_297# a_123_297# VPWR VPB abpmos
X30 a_321_297# SLEEP X VPB abpmos
X31 a_321_297# SLEEP X VPB abpmos
X32 a_321_297# SLEEP X VPB abpmos
X33 X SLEEP VGND VNB abnmos
X34 X SLEEP VGND VNB abnmos
X35 a_321_297# SLEEP X VPB abpmos
X36 a_321_297# SLEEP X VPB abpmos
X37 a_321_297# SLEEP X VPB abpmos
X38 X SLEEP VGND VNB abnmos
X39 X SLEEP VGND VNB abnmos
X40 a_321_297# a_123_297# VPWR VPB abpmos
X41 a_321_297# a_123_297# VPWR VPB abpmos
X42 a_321_297# a_123_297# VPWR VPB abpmos
X43 X a_123_297# VGND VNB abnmos
X44 X a_123_297# VGND VNB abnmos
X45 X SLEEP a_321_297# VPB abpmos
X46 X SLEEP a_321_297# VPB abpmos
X47 X SLEEP a_321_297# VPB abpmos
X48 a_123_297# A VGND VNB abnmos
X49 a_123_297# A VGND VNB abnmos
X50 X SLEEP VGND VNB abnmos
X51 X SLEEP VGND VNB abnmos
X52 X SLEEP a_321_297# VPB abpmos
X53 X SLEEP a_321_297# VPB abpmos
X54 X SLEEP a_321_297# VPB abpmos
X55 X a_123_297# VGND VNB abnmos
X56 X a_123_297# VGND VNB abnmos
X57 a_123_297# A VGND VNB abnmos
X58 a_123_297# A VGND VNB abnmos
X59 X a_123_297# VGND VNB abnmos
X60 X a_123_297# VGND VNB abnmos
X61 X a_123_297# VGND VNB abnmos
X62 X a_123_297# VGND VNB abnmos
X63 a_321_297# a_123_297# VPWR VPB abpmos
X64 a_321_297# a_123_297# VPWR VPB abpmos
X65 a_321_297# a_123_297# VPWR VPB abpmos
X66 X SLEEP VGND VNB abnmos
X67 X SLEEP VGND VNB abnmos
X68 a_321_297# a_123_297# VPWR VPB abpmos
X69 a_321_297# a_123_297# VPWR VPB abpmos
X70 a_321_297# a_123_297# VPWR VPB abpmos
X71 a_123_297# A VPWR VPB abpmos
X72 a_123_297# A VPWR VPB abpmos
X73 a_123_297# A VPWR VPB abpmos
X74 X SLEEP a_321_297# VPB abpmos
X75 X SLEEP a_321_297# VPB abpmos
X76 X SLEEP a_321_297# VPB abpmos
X77 X SLEEP a_321_297# VPB abpmos
X78 X SLEEP a_321_297# VPB abpmos
X79 X SLEEP a_321_297# VPB abpmos
X80 X SLEEP VGND VNB abnmos
X81 X SLEEP VGND VNB abnmos
X82 a_321_297# a_123_297# VPWR VPB abpmos
X83 a_321_297# a_123_297# VPWR VPB abpmos
X84 a_321_297# a_123_297# VPWR VPB abpmos
X85 X SLEEP VGND VNB abnmos
X86 X SLEEP VGND VNB abnmos
X87 a_321_297# SLEEP X VPB abpmos
X88 a_321_297# SLEEP X VPB abpmos
X89 a_321_297# SLEEP X VPB abpmos
.ends LPFLOW_ISOBUFSRCD8B
