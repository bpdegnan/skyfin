* DLCLKPD4 : abstract conversion of sky130_fd_sc_hd__dlclkp_4
* 50 abstract devices (width -> parallel min-width fingers)
.subckt DLCLKPD4 CLK GATE VGND VPWR GCLK
XDLCLKPD4B CLK GATE VGND VGND VPWR VPWR GCLK DLCLKPD4B
.ends DLCLKPD4

.subckt DLCLKPD4B CLK GATE VGND VNB VPB VPWR GCLK
X0 a_381_369# a_193_47# a_477_413# VPB abpmos
X1 a_1046_47# CLK VGND VNB abnmos
X2 a_1046_47# CLK VGND VNB abnmos
X3 GCLK a_953_297# VGND VNB abnmos
X4 GCLK a_953_297# VGND VNB abnmos
X5 a_477_413# a_193_47# a_575_47# VNB abnmos
X6 a_381_369# GATE VPWR VPB abpmos
X7 a_381_369# GATE VPWR VPB abpmos
X8 a_575_47# a_627_153# VGND VNB abnmos
X9 GCLK a_953_297# VGND VNB abnmos
X10 GCLK a_953_297# VGND VNB abnmos
X11 a_627_153# a_477_413# VPWR VPB abpmos
X12 a_627_153# a_477_413# VPWR VPB abpmos
X13 a_627_153# a_477_413# VPWR VPB abpmos
X14 a_953_297# CLK VPWR VPB abpmos
X15 a_953_297# CLK VPWR VPB abpmos
X16 a_953_297# CLK VPWR VPB abpmos
X17 a_953_297# a_627_153# a_1046_47# VNB abnmos
X18 a_953_297# a_627_153# a_1046_47# VNB abnmos
X19 GCLK a_953_297# VGND VNB abnmos
X20 GCLK a_953_297# VGND VNB abnmos
X21 GCLK a_953_297# VPWR VPB abpmos
X22 GCLK a_953_297# VPWR VPB abpmos
X23 GCLK a_953_297# VPWR VPB abpmos
X24 a_381_47# a_27_47# a_477_413# VNB abnmos
X25 a_953_297# a_627_153# VPWR VPB abpmos
X26 a_953_297# a_627_153# VPWR VPB abpmos
X27 a_953_297# a_627_153# VPWR VPB abpmos
X28 a_627_153# a_477_413# VGND VNB abnmos
X29 a_627_153# a_477_413# VGND VNB abnmos
X30 a_193_47# a_27_47# VGND VNB abnmos
X31 a_27_47# CLK VGND VNB abnmos
X32 a_27_47# CLK VPWR VPB abpmos
X33 a_27_47# CLK VPWR VPB abpmos
X34 GCLK a_953_297# VPWR VPB abpmos
X35 GCLK a_953_297# VPWR VPB abpmos
X36 GCLK a_953_297# VPWR VPB abpmos
X37 GCLK a_953_297# VPWR VPB abpmos
X38 GCLK a_953_297# VPWR VPB abpmos
X39 GCLK a_953_297# VPWR VPB abpmos
X40 a_193_47# a_27_47# VPWR VPB abpmos
X41 a_193_47# a_27_47# VPWR VPB abpmos
X42 a_381_47# GATE VGND VNB abnmos
X43 a_477_413# a_27_47# a_585_413# VPB abpmos
X44 a_585_413# a_627_153# VPWR VPB abpmos
X45 GCLK a_953_297# VPWR VPB abpmos
X46 GCLK a_953_297# VPWR VPB abpmos
X47 GCLK a_953_297# VPWR VPB abpmos
X48 GCLK a_953_297# VGND VNB abnmos
X49 GCLK a_953_297# VGND VNB abnmos
.ends DLCLKPD4B
