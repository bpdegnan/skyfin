* auto-generated runcell for DLCLKPD4
* NOTE: sequential cell -- combinational sweep only, not a functional test
.lib "$SPICE_LIB/sky130.lib.spice" tt
.include "$SPICE_DEVICES/devices.cir"
.include "dlclkpd4.cir"

.param pvdd=1.8V
VVPWR VDD 0 {pvdd}
V_GND VGND 0 0

V_GATE GATE 0 PWL( 0ns 0 10ns 0 10.1ns {pvdd} 20ns {pvdd} 20.1ns 0 30ns 0 30.1ns {pvdd} 40ns {pvdd} )
V_CLK CLK 0 PWL( 0ns 0 20ns 0 20.1ns {pvdd} 40ns {pvdd} )

X1 CLK GATE VGND VDD GCLK DLCLKPD4
CL_GCLK GCLK VGND 0.1f

.control
tran 0.05n 40n
wrdata result.raw v(GATE) v(CLK) v(GCLK)
.endc
.end
