* O211AID2 : abstract conversion of sky130_fd_sc_hd__o211ai_2
* 40 abstract devices (width -> parallel min-width fingers)
.subckt O211AID2 A1 A2 B1 C1 VGND VPWR Y
XO211AID2B A1 A2 B1 C1 VGND VGND VPWR VPWR Y O211AID2B
.ends O211AID2

.subckt O211AID2B A1 A2 B1 C1 VGND VNB VPB VPWR Y
X0 Y A2 a_487_297# VPB abpmos
X1 Y A2 a_487_297# VPB abpmos
X2 Y A2 a_487_297# VPB abpmos
X3 a_27_47# C1 Y VNB abnmos
X4 a_27_47# C1 Y VNB abnmos
X5 a_487_297# A2 Y VPB abpmos
X6 a_487_297# A2 Y VPB abpmos
X7 a_487_297# A2 Y VPB abpmos
X8 a_487_297# A1 VPWR VPB abpmos
X9 a_487_297# A1 VPWR VPB abpmos
X10 a_487_297# A1 VPWR VPB abpmos
X11 Y C1 VPWR VPB abpmos
X12 Y C1 VPWR VPB abpmos
X13 Y C1 VPWR VPB abpmos
X14 Y C1 a_27_47# VNB abnmos
X15 Y C1 a_27_47# VNB abnmos
X16 Y C1 VPWR VPB abpmos
X17 Y C1 VPWR VPB abpmos
X18 Y C1 VPWR VPB abpmos
X19 Y B1 VPWR VPB abpmos
X20 Y B1 VPWR VPB abpmos
X21 Y B1 VPWR VPB abpmos
X22 a_286_47# A2 VGND VNB abnmos
X23 a_286_47# A2 VGND VNB abnmos
X24 a_27_47# B1 a_286_47# VNB abnmos
X25 a_27_47# B1 a_286_47# VNB abnmos
X26 a_286_47# B1 a_27_47# VNB abnmos
X27 a_286_47# B1 a_27_47# VNB abnmos
X28 a_286_47# A1 VGND VNB abnmos
X29 a_286_47# A1 VGND VNB abnmos
X30 Y B1 VPWR VPB abpmos
X31 Y B1 VPWR VPB abpmos
X32 Y B1 VPWR VPB abpmos
X33 a_487_297# A1 VPWR VPB abpmos
X34 a_487_297# A1 VPWR VPB abpmos
X35 a_487_297# A1 VPWR VPB abpmos
X36 a_286_47# A2 VGND VNB abnmos
X37 a_286_47# A2 VGND VNB abnmos
X38 a_286_47# A1 VGND VNB abnmos
X39 a_286_47# A1 VGND VNB abnmos
.ends O211AID2B
