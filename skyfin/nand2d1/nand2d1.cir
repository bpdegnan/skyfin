* NAND2D1 : abstract conversion of sky130_fd_sc_hd__nand2_1
* 10 abstract devices (width -> parallel min-width fingers)
.subckt NAND2D1 A B VGND VPWR Y
XNAND2D1B A B VGND VGND VPWR VPWR Y NAND2D1B
.ends NAND2D1

.subckt NAND2D1B A B VGND VNB VPB VPWR Y
X0 Y A VPWR VPB abpmos
X1 Y A VPWR VPB abpmos
X2 Y A VPWR VPB abpmos
X3 Y B VPWR VPB abpmos
X4 Y B VPWR VPB abpmos
X5 Y B VPWR VPB abpmos
X6 a_113_47# B VGND VNB abnmos
X7 a_113_47# B VGND VNB abnmos
X8 a_113_47# A Y VNB abnmos
X9 a_113_47# A Y VNB abnmos
.ends NAND2D1B
