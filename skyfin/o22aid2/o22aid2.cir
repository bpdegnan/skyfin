* O22AID2 : abstract conversion of sky130_fd_sc_hd__o22ai_2
* 40 abstract devices (width -> parallel min-width fingers)
.subckt O22AID2 A1 A2 B1 B2 VGND VPWR Y
XO22AID2B A1 A2 B1 B2 VGND VGND VPWR VPWR Y O22AID2B
.ends O22AID2

.subckt O22AID2B A1 A2 B1 B2 VGND VNB VPB VPWR Y
X0 Y B2 a_27_47# VNB abnmos
X1 Y B2 a_27_47# VNB abnmos
X2 a_27_297# B1 VPWR VPB abpmos
X3 a_27_297# B1 VPWR VPB abpmos
X4 a_27_297# B1 VPWR VPB abpmos
X5 Y B2 a_27_297# VPB abpmos
X6 Y B2 a_27_297# VPB abpmos
X7 Y B2 a_27_297# VPB abpmos
X8 a_27_47# B2 Y VNB abnmos
X9 a_27_47# B2 Y VNB abnmos
X10 a_27_297# B2 Y VPB abpmos
X11 a_27_297# B2 Y VPB abpmos
X12 a_27_297# B2 Y VPB abpmos
X13 Y A2 a_475_297# VPB abpmos
X14 Y A2 a_475_297# VPB abpmos
X15 Y A2 a_475_297# VPB abpmos
X16 a_27_297# B1 VPWR VPB abpmos
X17 a_27_297# B1 VPWR VPB abpmos
X18 a_27_297# B1 VPWR VPB abpmos
X19 a_27_47# B1 Y VNB abnmos
X20 a_27_47# B1 Y VNB abnmos
X21 a_475_297# A2 Y VPB abpmos
X22 a_475_297# A2 Y VPB abpmos
X23 a_475_297# A2 Y VPB abpmos
X24 a_27_47# A1 VGND VNB abnmos
X25 a_27_47# A1 VGND VNB abnmos
X26 a_27_47# A2 VGND VNB abnmos
X27 a_27_47# A2 VGND VNB abnmos
X28 Y B1 a_27_47# VNB abnmos
X29 Y B1 a_27_47# VNB abnmos
X30 a_27_47# A2 VGND VNB abnmos
X31 a_27_47# A2 VGND VNB abnmos
X32 a_475_297# A1 VPWR VPB abpmos
X33 a_475_297# A1 VPWR VPB abpmos
X34 a_475_297# A1 VPWR VPB abpmos
X35 a_27_47# A1 VGND VNB abnmos
X36 a_27_47# A1 VGND VNB abnmos
X37 a_475_297# A1 VPWR VPB abpmos
X38 a_475_297# A1 VPWR VPB abpmos
X39 a_475_297# A1 VPWR VPB abpmos
.ends O22AID2B
