* CLKINVD16 : abstract conversion of sky130_fd_sc_hd__clkinv_16
* 88 abstract devices (width -> parallel min-width fingers)
.subckt CLKINVD16 A VGND VPWR Y
XCLKINVD16B A VGND VGND VPWR VPWR Y CLKINVD16B
.ends CLKINVD16

.subckt CLKINVD16B A VGND VNB VPB VPWR Y
X0 Y A VPWR VPB abpmos
X1 Y A VPWR VPB abpmos
X2 Y A VPWR VPB abpmos
X3 Y A VPWR VPB abpmos
X4 Y A VPWR VPB abpmos
X5 Y A VPWR VPB abpmos
X6 Y A VPWR VPB abpmos
X7 Y A VPWR VPB abpmos
X8 Y A VPWR VPB abpmos
X9 Y A VPWR VPB abpmos
X10 Y A VPWR VPB abpmos
X11 Y A VPWR VPB abpmos
X12 Y A VPWR VPB abpmos
X13 Y A VPWR VPB abpmos
X14 Y A VPWR VPB abpmos
X15 Y A VPWR VPB abpmos
X16 Y A VPWR VPB abpmos
X17 Y A VPWR VPB abpmos
X18 Y A VPWR VPB abpmos
X19 Y A VPWR VPB abpmos
X20 Y A VPWR VPB abpmos
X21 Y A VPWR VPB abpmos
X22 Y A VPWR VPB abpmos
X23 Y A VPWR VPB abpmos
X24 Y A VPWR VPB abpmos
X25 Y A VPWR VPB abpmos
X26 Y A VPWR VPB abpmos
X27 Y A VPWR VPB abpmos
X28 Y A VPWR VPB abpmos
X29 Y A VPWR VPB abpmos
X30 Y A VGND VNB abnmos
X31 Y A VPWR VPB abpmos
X32 Y A VPWR VPB abpmos
X33 Y A VPWR VPB abpmos
X34 Y A VGND VNB abnmos
X35 Y A VPWR VPB abpmos
X36 Y A VPWR VPB abpmos
X37 Y A VPWR VPB abpmos
X38 Y A VGND VNB abnmos
X39 Y A VGND VNB abnmos
X40 Y A VPWR VPB abpmos
X41 Y A VPWR VPB abpmos
X42 Y A VPWR VPB abpmos
X43 Y A VGND VNB abnmos
X44 Y A VPWR VPB abpmos
X45 Y A VPWR VPB abpmos
X46 Y A VPWR VPB abpmos
X47 Y A VGND VNB abnmos
X48 Y A VGND VNB abnmos
X49 Y A VPWR VPB abpmos
X50 Y A VPWR VPB abpmos
X51 Y A VPWR VPB abpmos
X52 Y A VPWR VPB abpmos
X53 Y A VPWR VPB abpmos
X54 Y A VPWR VPB abpmos
X55 Y A VGND VNB abnmos
X56 Y A VGND VNB abnmos
X57 Y A VPWR VPB abpmos
X58 Y A VPWR VPB abpmos
X59 Y A VPWR VPB abpmos
X60 Y A VGND VNB abnmos
X61 Y A VPWR VPB abpmos
X62 Y A VPWR VPB abpmos
X63 Y A VPWR VPB abpmos
X64 Y A VGND VNB abnmos
X65 Y A VPWR VPB abpmos
X66 Y A VPWR VPB abpmos
X67 Y A VPWR VPB abpmos
X68 Y A VPWR VPB abpmos
X69 Y A VPWR VPB abpmos
X70 Y A VPWR VPB abpmos
X71 Y A VGND VNB abnmos
X72 Y A VPWR VPB abpmos
X73 Y A VPWR VPB abpmos
X74 Y A VPWR VPB abpmos
X75 Y A VGND VNB abnmos
X76 Y A VPWR VPB abpmos
X77 Y A VPWR VPB abpmos
X78 Y A VPWR VPB abpmos
X79 Y A VGND VNB abnmos
X80 Y A VPWR VPB abpmos
X81 Y A VPWR VPB abpmos
X82 Y A VPWR VPB abpmos
X83 Y A VPWR VPB abpmos
X84 Y A VPWR VPB abpmos
X85 Y A VPWR VPB abpmos
X86 Y A VGND VNB abnmos
X87 Y A VGND VNB abnmos
.ends CLKINVD16B
