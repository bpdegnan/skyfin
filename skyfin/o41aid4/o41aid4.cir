* O41AID4 : abstract conversion of sky130_fd_sc_hd__o41ai_4
* 100 abstract devices (width -> parallel min-width fingers)
.subckt O41AID4 A1 A2 A3 A4 B1 VGND VPWR Y
XO41AID4B A1 A2 A3 A4 B1 VGND VGND VPWR VPWR Y O41AID4B
.ends O41AID4

.subckt O41AID4B A1 A2 A3 A4 B1 VGND VNB VPB VPWR Y
X0 a_1243_297# A1 VPWR VPB abpmos
X1 a_1243_297# A1 VPWR VPB abpmos
X2 a_1243_297# A1 VPWR VPB abpmos
X3 a_27_47# A3 VGND VNB abnmos
X4 a_27_47# A3 VGND VNB abnmos
X5 a_27_47# A2 VGND VNB abnmos
X6 a_27_47# A2 VGND VNB abnmos
X7 a_27_47# A3 VGND VNB abnmos
X8 a_27_47# A3 VGND VNB abnmos
X9 a_27_47# A4 VGND VNB abnmos
X10 a_27_47# A4 VGND VNB abnmos
X11 a_27_47# A4 VGND VNB abnmos
X12 a_27_47# A4 VGND VNB abnmos
X13 a_467_297# A4 Y VPB abpmos
X14 a_467_297# A4 Y VPB abpmos
X15 a_467_297# A4 Y VPB abpmos
X16 Y B1 a_27_47# VNB abnmos
X17 Y B1 a_27_47# VNB abnmos
X18 a_27_47# A1 VGND VNB abnmos
X19 a_27_47# A1 VGND VNB abnmos
X20 Y A4 a_467_297# VPB abpmos
X21 Y A4 a_467_297# VPB abpmos
X22 Y A4 a_467_297# VPB abpmos
X23 a_885_297# A2 a_1243_297# VPB abpmos
X24 a_885_297# A2 a_1243_297# VPB abpmos
X25 a_885_297# A2 a_1243_297# VPB abpmos
X26 a_885_297# A2 a_1243_297# VPB abpmos
X27 a_885_297# A2 a_1243_297# VPB abpmos
X28 a_885_297# A2 a_1243_297# VPB abpmos
X29 a_27_47# A2 VGND VNB abnmos
X30 a_27_47# A2 VGND VNB abnmos
X31 a_27_47# A1 VGND VNB abnmos
X32 a_27_47# A1 VGND VNB abnmos
X33 a_885_297# A3 a_467_297# VPB abpmos
X34 a_885_297# A3 a_467_297# VPB abpmos
X35 a_885_297# A3 a_467_297# VPB abpmos
X36 a_1243_297# A1 VPWR VPB abpmos
X37 a_1243_297# A1 VPWR VPB abpmos
X38 a_1243_297# A1 VPWR VPB abpmos
X39 a_1243_297# A2 a_885_297# VPB abpmos
X40 a_1243_297# A2 a_885_297# VPB abpmos
X41 a_1243_297# A2 a_885_297# VPB abpmos
X42 a_27_47# A4 VGND VNB abnmos
X43 a_27_47# A4 VGND VNB abnmos
X44 a_467_297# A3 a_885_297# VPB abpmos
X45 a_467_297# A3 a_885_297# VPB abpmos
X46 a_467_297# A3 a_885_297# VPB abpmos
X47 a_1243_297# A2 a_885_297# VPB abpmos
X48 a_1243_297# A2 a_885_297# VPB abpmos
X49 a_1243_297# A2 a_885_297# VPB abpmos
X50 a_27_47# A2 VGND VNB abnmos
X51 a_27_47# A2 VGND VNB abnmos
X52 a_27_47# A1 VGND VNB abnmos
X53 a_27_47# A1 VGND VNB abnmos
X54 a_27_47# B1 Y VNB abnmos
X55 a_27_47# B1 Y VNB abnmos
X56 a_27_47# A4 VGND VNB abnmos
X57 a_27_47# A4 VGND VNB abnmos
X58 a_1243_297# A1 VPWR VPB abpmos
X59 a_1243_297# A1 VPWR VPB abpmos
X60 a_1243_297# A1 VPWR VPB abpmos
X61 a_885_297# A3 a_467_297# VPB abpmos
X62 a_885_297# A3 a_467_297# VPB abpmos
X63 a_885_297# A3 a_467_297# VPB abpmos
X64 Y B1 a_27_47# VNB abnmos
X65 Y B1 a_27_47# VNB abnmos
X66 a_27_47# A1 VGND VNB abnmos
X67 a_27_47# A1 VGND VNB abnmos
X68 Y B1 VPWR VPB abpmos
X69 Y B1 VPWR VPB abpmos
X70 Y B1 VPWR VPB abpmos
X71 a_467_297# A4 Y VPB abpmos
X72 a_467_297# A4 Y VPB abpmos
X73 a_467_297# A4 Y VPB abpmos
X74 a_27_47# B1 Y VNB abnmos
X75 a_27_47# B1 Y VNB abnmos
X76 a_467_297# A3 a_885_297# VPB abpmos
X77 a_467_297# A3 a_885_297# VPB abpmos
X78 a_467_297# A3 a_885_297# VPB abpmos
X79 a_1243_297# A1 VPWR VPB abpmos
X80 a_1243_297# A1 VPWR VPB abpmos
X81 a_1243_297# A1 VPWR VPB abpmos
X82 Y B1 VPWR VPB abpmos
X83 Y B1 VPWR VPB abpmos
X84 Y B1 VPWR VPB abpmos
X85 Y B1 VPWR VPB abpmos
X86 Y B1 VPWR VPB abpmos
X87 Y B1 VPWR VPB abpmos
X88 a_27_47# A3 VGND VNB abnmos
X89 a_27_47# A3 VGND VNB abnmos
X90 Y A4 a_467_297# VPB abpmos
X91 Y A4 a_467_297# VPB abpmos
X92 Y A4 a_467_297# VPB abpmos
X93 a_27_47# A2 VGND VNB abnmos
X94 a_27_47# A2 VGND VNB abnmos
X95 Y B1 VPWR VPB abpmos
X96 Y B1 VPWR VPB abpmos
X97 Y B1 VPWR VPB abpmos
X98 a_27_47# A3 VGND VNB abnmos
X99 a_27_47# A3 VGND VNB abnmos
.ends O41AID4B
