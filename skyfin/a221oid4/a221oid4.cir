* A221OID4 : abstract conversion of sky130_fd_sc_hd__a221oi_4
* 100 abstract devices (width -> parallel min-width fingers)
.subckt A221OID4 A1 A2 B1 B2 C1 VGND VPWR Y
XA221OID4B A1 A2 B1 B2 C1 VGND VGND VPWR VPWR Y A221OID4B
.ends A221OID4

.subckt A221OID4B A1 A2 B1 B2 C1 VGND VNB VPB VPWR Y
X0 a_471_297# B1 a_27_297# VPB abpmos
X1 a_471_297# B1 a_27_297# VPB abpmos
X2 a_471_297# B1 a_27_297# VPB abpmos
X3 Y C1 VGND VNB abnmos
X4 Y C1 VGND VNB abnmos
X5 a_1241_47# A1 Y VNB abnmos
X6 a_1241_47# A1 Y VNB abnmos
X7 Y C1 a_27_297# VPB abpmos
X8 Y C1 a_27_297# VPB abpmos
X9 Y C1 a_27_297# VPB abpmos
X10 Y C1 a_27_297# VPB abpmos
X11 Y C1 a_27_297# VPB abpmos
X12 Y C1 a_27_297# VPB abpmos
X13 a_27_297# B1 a_471_297# VPB abpmos
X14 a_27_297# B1 a_471_297# VPB abpmos
X15 a_27_297# B1 a_471_297# VPB abpmos
X16 a_471_297# A2 VPWR VPB abpmos
X17 a_471_297# A2 VPWR VPB abpmos
X18 a_471_297# A2 VPWR VPB abpmos
X19 a_27_297# B1 a_471_297# VPB abpmos
X20 a_27_297# B1 a_471_297# VPB abpmos
X21 a_27_297# B1 a_471_297# VPB abpmos
X22 Y C1 VGND VNB abnmos
X23 Y C1 VGND VNB abnmos
X24 a_1241_47# A2 VGND VNB abnmos
X25 a_1241_47# A2 VGND VNB abnmos
X26 a_27_297# C1 Y VPB abpmos
X27 a_27_297# C1 Y VPB abpmos
X28 a_27_297# C1 Y VPB abpmos
X29 a_471_297# B2 a_27_297# VPB abpmos
X30 a_471_297# B2 a_27_297# VPB abpmos
X31 a_471_297# B2 a_27_297# VPB abpmos
X32 a_27_297# C1 Y VPB abpmos
X33 a_27_297# C1 Y VPB abpmos
X34 a_27_297# C1 Y VPB abpmos
X35 Y C1 VGND VNB abnmos
X36 Y C1 VGND VNB abnmos
X37 a_453_47# B2 VGND VNB abnmos
X38 a_453_47# B2 VGND VNB abnmos
X39 a_471_297# A1 VPWR VPB abpmos
X40 a_471_297# A1 VPWR VPB abpmos
X41 a_471_297# A1 VPWR VPB abpmos
X42 a_471_297# A1 VPWR VPB abpmos
X43 a_471_297# A1 VPWR VPB abpmos
X44 a_471_297# A1 VPWR VPB abpmos
X45 Y A1 a_1241_47# VNB abnmos
X46 Y A1 a_1241_47# VNB abnmos
X47 a_1241_47# A2 VGND VNB abnmos
X48 a_1241_47# A2 VGND VNB abnmos
X49 a_453_47# B2 VGND VNB abnmos
X50 a_453_47# B2 VGND VNB abnmos
X51 a_471_297# A2 VPWR VPB abpmos
X52 a_471_297# A2 VPWR VPB abpmos
X53 a_471_297# A2 VPWR VPB abpmos
X54 a_453_47# B2 VGND VNB abnmos
X55 a_453_47# B2 VGND VNB abnmos
X56 a_453_47# B1 Y VNB abnmos
X57 a_453_47# B1 Y VNB abnmos
X58 a_471_297# A1 VPWR VPB abpmos
X59 a_471_297# A1 VPWR VPB abpmos
X60 a_471_297# A1 VPWR VPB abpmos
X61 a_471_297# A1 VPWR VPB abpmos
X62 a_471_297# A1 VPWR VPB abpmos
X63 a_471_297# A1 VPWR VPB abpmos
X64 Y C1 VGND VNB abnmos
X65 Y C1 VGND VNB abnmos
X66 a_453_47# B2 VGND VNB abnmos
X67 a_453_47# B2 VGND VNB abnmos
X68 a_1241_47# A1 Y VNB abnmos
X69 a_1241_47# A1 Y VNB abnmos
X70 a_1241_47# A2 VGND VNB abnmos
X71 a_1241_47# A2 VGND VNB abnmos
X72 a_27_297# B2 a_471_297# VPB abpmos
X73 a_27_297# B2 a_471_297# VPB abpmos
X74 a_27_297# B2 a_471_297# VPB abpmos
X75 a_471_297# A2 VPWR VPB abpmos
X76 a_471_297# A2 VPWR VPB abpmos
X77 a_471_297# A2 VPWR VPB abpmos
X78 a_471_297# B2 a_27_297# VPB abpmos
X79 a_471_297# B2 a_27_297# VPB abpmos
X80 a_471_297# B2 a_27_297# VPB abpmos
X81 a_1241_47# A2 VGND VNB abnmos
X82 a_1241_47# A2 VGND VNB abnmos
X83 a_471_297# B1 a_27_297# VPB abpmos
X84 a_471_297# B1 a_27_297# VPB abpmos
X85 a_471_297# B1 a_27_297# VPB abpmos
X86 a_471_297# A2 VPWR VPB abpmos
X87 a_471_297# A2 VPWR VPB abpmos
X88 a_471_297# A2 VPWR VPB abpmos
X89 Y B1 a_453_47# VNB abnmos
X90 Y B1 a_453_47# VNB abnmos
X91 a_27_297# B2 a_471_297# VPB abpmos
X92 a_27_297# B2 a_471_297# VPB abpmos
X93 a_27_297# B2 a_471_297# VPB abpmos
X94 Y B1 a_453_47# VNB abnmos
X95 Y B1 a_453_47# VNB abnmos
X96 Y A1 a_1241_47# VNB abnmos
X97 Y A1 a_1241_47# VNB abnmos
X98 a_453_47# B1 Y VNB abnmos
X99 a_453_47# B1 Y VNB abnmos
.ends A221OID4B
