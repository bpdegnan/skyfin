* A21OID4 : abstract conversion of sky130_fd_sc_hd__a21oi_4
* 60 abstract devices (width -> parallel min-width fingers)
.subckt A21OID4 A1 A2 B1 VGND VPWR Y
XA21OID4B A1 A2 B1 VGND VGND VPWR VPWR Y A21OID4B
.ends A21OID4

.subckt A21OID4B A1 A2 B1 VGND VNB VPB VPWR Y
X0 a_462_47# A2 VGND VNB abnmos
X1 a_462_47# A2 VGND VNB abnmos
X2 Y B1 a_28_297# VPB abpmos
X3 Y B1 a_28_297# VPB abpmos
X4 Y B1 a_28_297# VPB abpmos
X5 a_28_297# A2 VPWR VPB abpmos
X6 a_28_297# A2 VPWR VPB abpmos
X7 a_28_297# A2 VPWR VPB abpmos
X8 Y B1 VGND VNB abnmos
X9 Y B1 VGND VNB abnmos
X10 a_28_297# A1 VPWR VPB abpmos
X11 a_28_297# A1 VPWR VPB abpmos
X12 a_28_297# A1 VPWR VPB abpmos
X13 a_28_297# B1 Y VPB abpmos
X14 a_28_297# B1 Y VPB abpmos
X15 a_28_297# B1 Y VPB abpmos
X16 a_28_297# A1 VPWR VPB abpmos
X17 a_28_297# A1 VPWR VPB abpmos
X18 a_28_297# A1 VPWR VPB abpmos
X19 a_28_297# A1 VPWR VPB abpmos
X20 a_28_297# A1 VPWR VPB abpmos
X21 a_28_297# A1 VPWR VPB abpmos
X22 Y B1 VGND VNB abnmos
X23 Y B1 VGND VNB abnmos
X24 Y B1 a_28_297# VPB abpmos
X25 Y B1 a_28_297# VPB abpmos
X26 Y B1 a_28_297# VPB abpmos
X27 a_28_297# B1 Y VPB abpmos
X28 a_28_297# B1 Y VPB abpmos
X29 a_28_297# B1 Y VPB abpmos
X30 a_28_297# A2 VPWR VPB abpmos
X31 a_28_297# A2 VPWR VPB abpmos
X32 a_28_297# A2 VPWR VPB abpmos
X33 a_28_297# A2 VPWR VPB abpmos
X34 a_28_297# A2 VPWR VPB abpmos
X35 a_28_297# A2 VPWR VPB abpmos
X36 a_462_47# A1 Y VNB abnmos
X37 a_462_47# A1 Y VNB abnmos
X38 a_28_297# A1 VPWR VPB abpmos
X39 a_28_297# A1 VPWR VPB abpmos
X40 a_28_297# A1 VPWR VPB abpmos
X41 a_28_297# A2 VPWR VPB abpmos
X42 a_28_297# A2 VPWR VPB abpmos
X43 a_28_297# A2 VPWR VPB abpmos
X44 a_462_47# A2 VGND VNB abnmos
X45 a_462_47# A2 VGND VNB abnmos
X46 a_462_47# A2 VGND VNB abnmos
X47 a_462_47# A2 VGND VNB abnmos
X48 Y A1 a_462_47# VNB abnmos
X49 Y A1 a_462_47# VNB abnmos
X50 a_462_47# A2 VGND VNB abnmos
X51 a_462_47# A2 VGND VNB abnmos
X52 Y B1 VGND VNB abnmos
X53 Y B1 VGND VNB abnmos
X54 Y B1 VGND VNB abnmos
X55 Y B1 VGND VNB abnmos
X56 a_462_47# A1 Y VNB abnmos
X57 a_462_47# A1 Y VNB abnmos
X58 Y A1 a_462_47# VNB abnmos
X59 Y A1 a_462_47# VNB abnmos
.ends A21OID4B
