* AND2D4 : abstract conversion of sky130_fd_sc_hd__and2_4
* 30 abstract devices (width -> parallel min-width fingers)
.subckt AND2D4 A B VGND VPWR X
XAND2D4B A B VGND VGND VPWR VPWR X AND2D4B
.ends AND2D4

.subckt AND2D4B A B VGND VNB VPB VPWR X
X0 a_27_47# B VPWR VPB abpmos
X1 a_27_47# B VPWR VPB abpmos
X2 a_27_47# B VPWR VPB abpmos
X3 a_27_47# A VPWR VPB abpmos
X4 a_27_47# A VPWR VPB abpmos
X5 a_27_47# A VPWR VPB abpmos
X6 a_110_47# B VGND VNB abnmos
X7 a_110_47# B VGND VNB abnmos
X8 X a_27_47# VGND VNB abnmos
X9 X a_27_47# VGND VNB abnmos
X10 a_27_47# A a_110_47# VNB abnmos
X11 a_27_47# A a_110_47# VNB abnmos
X12 X a_27_47# VGND VNB abnmos
X13 X a_27_47# VGND VNB abnmos
X14 X a_27_47# VPWR VPB abpmos
X15 X a_27_47# VPWR VPB abpmos
X16 X a_27_47# VPWR VPB abpmos
X17 X a_27_47# VPWR VPB abpmos
X18 X a_27_47# VPWR VPB abpmos
X19 X a_27_47# VPWR VPB abpmos
X20 X a_27_47# VGND VNB abnmos
X21 X a_27_47# VGND VNB abnmos
X22 X a_27_47# VPWR VPB abpmos
X23 X a_27_47# VPWR VPB abpmos
X24 X a_27_47# VPWR VPB abpmos
X25 X a_27_47# VGND VNB abnmos
X26 X a_27_47# VGND VNB abnmos
X27 X a_27_47# VPWR VPB abpmos
X28 X a_27_47# VPWR VPB abpmos
X29 X a_27_47# VPWR VPB abpmos
.ends AND2D4B
