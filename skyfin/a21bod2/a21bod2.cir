* A21BOD2 : abstract conversion of sky130_fd_sc_hd__a21bo_2
* 27 abstract devices (width -> parallel min-width fingers)
.subckt A21BOD2 A1 A2 B1_N VGND VPWR X
XA21BOD2B A1 A2 B1_N VGND VGND VPWR VPWR X A21BOD2B
.ends A21BOD2

.subckt A21BOD2B A1 A2 B1_N VGND VNB VPB VPWR X
X0 X a_79_21# VGND VNB abnmos
X1 X a_79_21# VGND VNB abnmos
X2 a_79_21# A1 a_581_47# VNB abnmos
X3 a_79_21# A1 a_581_47# VNB abnmos
X4 a_297_93# B1_N VPWR VPB abpmos
X5 a_79_21# a_297_93# VGND VNB abnmos
X6 a_79_21# a_297_93# VGND VNB abnmos
X7 X a_79_21# VGND VNB abnmos
X8 X a_79_21# VGND VNB abnmos
X9 a_485_297# A1 VPWR VPB abpmos
X10 a_485_297# A1 VPWR VPB abpmos
X11 a_485_297# A1 VPWR VPB abpmos
X12 a_581_47# A2 VGND VNB abnmos
X13 a_581_47# A2 VGND VNB abnmos
X14 X a_79_21# VPWR VPB abpmos
X15 X a_79_21# VPWR VPB abpmos
X16 X a_79_21# VPWR VPB abpmos
X17 a_79_21# a_297_93# a_485_297# VPB abpmos
X18 a_79_21# a_297_93# a_485_297# VPB abpmos
X19 a_79_21# a_297_93# a_485_297# VPB abpmos
X20 a_485_297# A2 VPWR VPB abpmos
X21 a_485_297# A2 VPWR VPB abpmos
X22 a_485_297# A2 VPWR VPB abpmos
X23 X a_79_21# VPWR VPB abpmos
X24 X a_79_21# VPWR VPB abpmos
X25 X a_79_21# VPWR VPB abpmos
X26 a_297_93# B1_N VGND VNB abnmos
.ends A21BOD2B
