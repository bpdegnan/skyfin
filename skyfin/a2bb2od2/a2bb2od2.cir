* A2BB2OD2 : abstract conversion of sky130_fd_sc_hd__a2bb2o_2
* 25 abstract devices (width -> parallel min-width fingers)
.subckt A2BB2OD2 A1_N A2_N B1 B2 VGND VPWR X
XA2BB2OD2B A1_N A2_N B1 B2 VGND VGND VPWR VPWR X A2BB2OD2B
.ends A2BB2OD2

.subckt A2BB2OD2B A1_N A2_N B1 B2 VGND VNB VPB VPWR X
X0 a_313_47# A1_N VGND VNB abnmos
X1 X a_82_21# VPWR VPB abpmos
X2 X a_82_21# VPWR VPB abpmos
X3 X a_82_21# VPWR VPB abpmos
X4 a_82_21# a_313_47# a_574_369# VPB abpmos
X5 a_82_21# a_313_47# a_574_369# VPB abpmos
X6 a_82_21# B2 a_646_47# VNB abnmos
X7 a_82_21# a_313_47# VGND VNB abnmos
X8 X a_82_21# VPWR VPB abpmos
X9 X a_82_21# VPWR VPB abpmos
X10 X a_82_21# VPWR VPB abpmos
X11 a_574_369# B1 VPWR VPB abpmos
X12 a_574_369# B1 VPWR VPB abpmos
X13 a_574_369# B2 VPWR VPB abpmos
X14 a_574_369# B2 VPWR VPB abpmos
X15 a_313_297# A1_N VPWR VPB abpmos
X16 a_313_297# A1_N VPWR VPB abpmos
X17 a_313_297# A2_N a_313_47# VPB abpmos
X18 a_313_297# A2_N a_313_47# VPB abpmos
X19 X a_82_21# VGND VNB abnmos
X20 X a_82_21# VGND VNB abnmos
X21 a_646_47# B1 VGND VNB abnmos
X22 X a_82_21# VGND VNB abnmos
X23 X a_82_21# VGND VNB abnmos
X24 a_313_47# A2_N VGND VNB abnmos
.ends A2BB2OD2B
