* NOR4D2 : abstract conversion of sky130_fd_sc_hd__nor4_2
* 40 abstract devices (width -> parallel min-width fingers)
.subckt NOR4D2 A B C D VGND VPWR Y
XNOR4D2B A B C D VGND VGND VPWR VPWR Y NOR4D2B
.ends NOR4D2

.subckt NOR4D2B A B C D VGND VNB VPB VPWR Y
X0 Y B VGND VNB abnmos
X1 Y B VGND VNB abnmos
X2 a_27_297# A VPWR VPB abpmos
X3 a_27_297# A VPWR VPB abpmos
X4 a_27_297# A VPWR VPB abpmos
X5 a_281_297# B a_27_297# VPB abpmos
X6 a_281_297# B a_27_297# VPB abpmos
X7 a_281_297# B a_27_297# VPB abpmos
X8 Y B VGND VNB abnmos
X9 Y B VGND VNB abnmos
X10 a_27_297# B a_281_297# VPB abpmos
X11 a_27_297# B a_281_297# VPB abpmos
X12 a_27_297# B a_281_297# VPB abpmos
X13 a_281_297# C a_475_297# VPB abpmos
X14 a_281_297# C a_475_297# VPB abpmos
X15 a_281_297# C a_475_297# VPB abpmos
X16 a_27_297# A VPWR VPB abpmos
X17 a_27_297# A VPWR VPB abpmos
X18 a_27_297# A VPWR VPB abpmos
X19 Y A VGND VNB abnmos
X20 Y A VGND VNB abnmos
X21 a_475_297# C a_281_297# VPB abpmos
X22 a_475_297# C a_281_297# VPB abpmos
X23 a_475_297# C a_281_297# VPB abpmos
X24 Y D VGND VNB abnmos
X25 Y D VGND VNB abnmos
X26 Y C VGND VNB abnmos
X27 Y C VGND VNB abnmos
X28 Y A VGND VNB abnmos
X29 Y A VGND VNB abnmos
X30 Y C VGND VNB abnmos
X31 Y C VGND VNB abnmos
X32 a_475_297# D Y VPB abpmos
X33 a_475_297# D Y VPB abpmos
X34 a_475_297# D Y VPB abpmos
X35 Y D VGND VNB abnmos
X36 Y D VGND VNB abnmos
X37 Y D a_475_297# VPB abpmos
X38 Y D a_475_297# VPB abpmos
X39 Y D a_475_297# VPB abpmos
.ends NOR4D2B
