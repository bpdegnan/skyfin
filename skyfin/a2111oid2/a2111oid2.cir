* A2111OID2 : abstract conversion of sky130_fd_sc_hd__a2111oi_2
* 50 abstract devices (width -> parallel min-width fingers)
.subckt A2111OID2 A1 A2 B1 C1 D1 VGND VPWR Y
XA2111OID2B A1 A2 B1 C1 D1 VGND VGND VPWR VPWR Y A2111OID2B
.ends A2111OID2

.subckt A2111OID2B A1 A2 B1 C1 D1 VGND VNB VPB VPWR Y
X0 Y D1 VGND VNB abnmos
X1 Y D1 VGND VNB abnmos
X2 a_467_297# A2 VPWR VPB abpmos
X3 a_467_297# A2 VPWR VPB abpmos
X4 a_467_297# A2 VPWR VPB abpmos
X5 a_923_47# A1 Y VNB abnmos
X6 a_923_47# A1 Y VNB abnmos
X7 a_467_297# A1 VPWR VPB abpmos
X8 a_467_297# A1 VPWR VPB abpmos
X9 a_467_297# A1 VPWR VPB abpmos
X10 Y D1 VGND VNB abnmos
X11 Y D1 VGND VNB abnmos
X12 a_28_297# C1 a_115_297# VPB abpmos
X13 a_28_297# C1 a_115_297# VPB abpmos
X14 a_28_297# C1 a_115_297# VPB abpmos
X15 a_28_297# B1 a_467_297# VPB abpmos
X16 a_28_297# B1 a_467_297# VPB abpmos
X17 a_28_297# B1 a_467_297# VPB abpmos
X18 Y C1 VGND VNB abnmos
X19 Y C1 VGND VNB abnmos
X20 Y D1 a_287_297# VPB abpmos
X21 Y D1 a_287_297# VPB abpmos
X22 Y D1 a_287_297# VPB abpmos
X23 a_115_297# D1 Y VPB abpmos
X24 a_115_297# D1 Y VPB abpmos
X25 a_115_297# D1 Y VPB abpmos
X26 Y B1 VGND VNB abnmos
X27 Y B1 VGND VNB abnmos
X28 a_467_297# B1 a_28_297# VPB abpmos
X29 a_467_297# B1 a_28_297# VPB abpmos
X30 a_467_297# B1 a_28_297# VPB abpmos
X31 a_467_297# A1 VPWR VPB abpmos
X32 a_467_297# A1 VPWR VPB abpmos
X33 a_467_297# A1 VPWR VPB abpmos
X34 Y C1 VGND VNB abnmos
X35 Y C1 VGND VNB abnmos
X36 a_287_297# C1 a_28_297# VPB abpmos
X37 a_287_297# C1 a_28_297# VPB abpmos
X38 a_287_297# C1 a_28_297# VPB abpmos
X39 a_467_297# A2 VPWR VPB abpmos
X40 a_467_297# A2 VPWR VPB abpmos
X41 a_467_297# A2 VPWR VPB abpmos
X42 a_923_47# A2 VGND VNB abnmos
X43 a_923_47# A2 VGND VNB abnmos
X44 a_684_47# A2 VGND VNB abnmos
X45 a_684_47# A2 VGND VNB abnmos
X46 Y B1 VGND VNB abnmos
X47 Y B1 VGND VNB abnmos
X48 Y A1 a_684_47# VNB abnmos
X49 Y A1 a_684_47# VNB abnmos
.ends A2111OID2B
