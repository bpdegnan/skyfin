* O32AD4 : abstract conversion of sky130_fd_sc_hd__o32a_4
* 70 abstract devices (width -> parallel min-width fingers)
.subckt O32AD4 A1 A2 A3 B1 B2 VGND VPWR X
XO32AD4B A1 A2 A3 B1 B2 VGND VGND VPWR VPWR X O32AD4B
.ends O32AD4

.subckt O32AD4B A1 A2 A3 B1 B2 VGND VNB VPB VPWR X
X0 X a_549_297# VPWR VPB abpmos
X1 X a_549_297# VPWR VPB abpmos
X2 X a_549_297# VPWR VPB abpmos
X3 X a_549_297# VGND VNB abnmos
X4 X a_549_297# VGND VNB abnmos
X5 X a_549_297# VPWR VPB abpmos
X6 X a_549_297# VPWR VPB abpmos
X7 X a_549_297# VPWR VPB abpmos
X8 a_277_297# A3 a_549_297# VPB abpmos
X9 a_277_297# A3 a_549_297# VPB abpmos
X10 a_277_297# A3 a_549_297# VPB abpmos
X11 a_739_297# B2 a_549_297# VPB abpmos
X12 a_739_297# B2 a_549_297# VPB abpmos
X13 a_739_297# B2 a_549_297# VPB abpmos
X14 a_27_47# A2 VGND VNB abnmos
X15 a_27_47# A2 VGND VNB abnmos
X16 a_739_297# B1 VPWR VPB abpmos
X17 a_739_297# B1 VPWR VPB abpmos
X18 a_739_297# B1 VPWR VPB abpmos
X19 a_549_297# A3 a_277_297# VPB abpmos
X20 a_549_297# A3 a_277_297# VPB abpmos
X21 a_549_297# A3 a_277_297# VPB abpmos
X22 a_549_297# B2 a_739_297# VPB abpmos
X23 a_549_297# B2 a_739_297# VPB abpmos
X24 a_549_297# B2 a_739_297# VPB abpmos
X25 X a_549_297# VPWR VPB abpmos
X26 X a_549_297# VPWR VPB abpmos
X27 X a_549_297# VPWR VPB abpmos
X28 a_739_297# B1 VPWR VPB abpmos
X29 a_739_297# B1 VPWR VPB abpmos
X30 a_739_297# B1 VPWR VPB abpmos
X31 a_549_297# B2 a_27_47# VNB abnmos
X32 a_549_297# B2 a_27_47# VNB abnmos
X33 a_27_47# A3 VGND VNB abnmos
X34 a_27_47# A3 VGND VNB abnmos
X35 a_27_47# A2 VGND VNB abnmos
X36 a_27_47# A2 VGND VNB abnmos
X37 X a_549_297# VGND VNB abnmos
X38 X a_549_297# VGND VNB abnmos
X39 a_27_47# B1 a_549_297# VNB abnmos
X40 a_27_47# B1 a_549_297# VNB abnmos
X41 X a_549_297# VGND VNB abnmos
X42 X a_549_297# VGND VNB abnmos
X43 a_27_47# A1 VGND VNB abnmos
X44 a_27_47# A1 VGND VNB abnmos
X45 a_27_297# A2 a_277_297# VPB abpmos
X46 a_27_297# A2 a_277_297# VPB abpmos
X47 a_27_297# A2 a_277_297# VPB abpmos
X48 a_27_47# A1 VGND VNB abnmos
X49 a_27_47# A1 VGND VNB abnmos
X50 a_549_297# B1 a_27_47# VNB abnmos
X51 a_549_297# B1 a_27_47# VNB abnmos
X52 a_27_297# A1 VPWR VPB abpmos
X53 a_27_297# A1 VPWR VPB abpmos
X54 a_27_297# A1 VPWR VPB abpmos
X55 a_27_297# A1 VPWR VPB abpmos
X56 a_27_297# A1 VPWR VPB abpmos
X57 a_27_297# A1 VPWR VPB abpmos
X58 X a_549_297# VGND VNB abnmos
X59 X a_549_297# VGND VNB abnmos
X60 a_27_47# A3 VGND VNB abnmos
X61 a_27_47# A3 VGND VNB abnmos
X62 a_277_297# A2 a_27_297# VPB abpmos
X63 a_277_297# A2 a_27_297# VPB abpmos
X64 a_277_297# A2 a_27_297# VPB abpmos
X65 a_27_47# B2 a_549_297# VNB abnmos
X66 a_27_47# B2 a_549_297# VNB abnmos
X67 X a_549_297# VPWR VPB abpmos
X68 X a_549_297# VPWR VPB abpmos
X69 X a_549_297# VPWR VPB abpmos
.ends O32AD4B
