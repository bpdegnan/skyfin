* A41OD2 : abstract conversion of sky130_fd_sc_hd__a41o_2
* 35 abstract devices (width -> parallel min-width fingers)
.subckt A41OD2 A1 A2 A3 A4 B1 VGND VPWR X
XA41OD2B A1 A2 A3 A4 B1 VGND VGND VPWR VPWR X A41OD2B
.ends A41OD2

.subckt A41OD2B A1 A2 A3 A4 B1 VGND VNB VPB VPWR X
X0 a_549_47# A2 a_665_47# VNB abnmos
X1 a_549_47# A2 a_665_47# VNB abnmos
X2 a_381_297# A3 VPWR VPB abpmos
X3 a_381_297# A3 VPWR VPB abpmos
X4 a_381_297# A3 VPWR VPB abpmos
X5 a_381_297# A4 VPWR VPB abpmos
X6 a_381_297# A4 VPWR VPB abpmos
X7 a_381_297# A4 VPWR VPB abpmos
X8 a_79_21# B1 a_381_297# VPB abpmos
X9 a_79_21# B1 a_381_297# VPB abpmos
X10 a_79_21# B1 a_381_297# VPB abpmos
X11 a_465_47# A3 a_549_47# VNB abnmos
X12 a_465_47# A3 a_549_47# VNB abnmos
X13 a_381_297# A1 VPWR VPB abpmos
X14 a_381_297# A1 VPWR VPB abpmos
X15 a_381_297# A1 VPWR VPB abpmos
X16 a_465_47# A4 VGND VNB abnmos
X17 a_465_47# A4 VGND VNB abnmos
X18 X a_79_21# VGND VNB abnmos
X19 X a_79_21# VGND VNB abnmos
X20 X a_79_21# VGND VNB abnmos
X21 X a_79_21# VGND VNB abnmos
X22 a_381_297# A2 VPWR VPB abpmos
X23 a_381_297# A2 VPWR VPB abpmos
X24 a_381_297# A2 VPWR VPB abpmos
X25 X a_79_21# VPWR VPB abpmos
X26 X a_79_21# VPWR VPB abpmos
X27 X a_79_21# VPWR VPB abpmos
X28 a_79_21# B1 VGND VNB abnmos
X29 a_79_21# B1 VGND VNB abnmos
X30 X a_79_21# VPWR VPB abpmos
X31 X a_79_21# VPWR VPB abpmos
X32 X a_79_21# VPWR VPB abpmos
X33 a_665_47# A1 a_79_21# VNB abnmos
X34 a_665_47# A1 a_79_21# VNB abnmos
.ends A41OD2B
