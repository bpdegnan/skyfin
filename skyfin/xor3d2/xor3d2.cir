* XOR3D2 : abstract conversion of sky130_fd_sc_hd__xor3_2
* 51 abstract devices (width -> parallel min-width fingers)
.subckt XOR3D2 A B C VGND VPWR X
XXOR3D2B A B C VGND VGND VPWR VPWR X XOR3D2B
.ends XOR3D2

.subckt XOR3D2B A B C VGND VNB VPB VPWR X
X0 a_478_325# C a_120_21# VPB abpmos
X1 a_478_325# C a_120_21# VPB abpmos
X2 a_358_93# C VGND VNB abnmos
X3 a_919_297# B VGND VNB abnmos
X4 a_919_297# B VGND VNB abnmos
X5 a_1290_49# a_1023_365# VPWR VPB abpmos
X6 a_1290_49# a_1023_365# VPWR VPB abpmos
X7 a_1290_49# a_1023_365# VPWR VPB abpmos
X8 a_1290_49# B a_478_325# VNB abnmos
X9 a_1290_49# B a_478_325# VNB abnmos
X10 a_1023_365# A VGND VNB abnmos
X11 a_1023_365# A VGND VNB abnmos
X12 X a_120_21# VGND VNB abnmos
X13 X a_120_21# VGND VNB abnmos
X14 a_919_297# B VPWR VPB abpmos
X15 a_919_297# B VPWR VPB abpmos
X16 a_919_297# B VPWR VPB abpmos
X17 X a_120_21# VGND VNB abnmos
X18 X a_120_21# VGND VNB abnmos
X19 a_1290_49# B a_496_49# VPB abpmos
X20 a_1290_49# B a_496_49# VPB abpmos
X21 a_496_49# C a_120_21# VNB abnmos
X22 a_496_49# C a_120_21# VNB abnmos
X23 a_1023_365# B a_478_325# VPB abpmos
X24 a_1023_365# B a_478_325# VPB abpmos
X25 a_358_93# C VPWR VPB abpmos
X26 a_358_93# C VPWR VPB abpmos
X27 a_478_325# a_919_297# a_1023_365# VNB abnmos
X28 a_478_325# a_919_297# a_1023_365# VNB abnmos
X29 a_496_49# a_919_297# a_1290_49# VNB abnmos
X30 a_120_21# a_358_93# a_496_49# VPB abpmos
X31 a_120_21# a_358_93# a_496_49# VPB abpmos
X32 a_1023_365# B a_496_49# VNB abnmos
X33 a_1023_365# B a_496_49# VNB abnmos
X34 X a_120_21# VPWR VPB abpmos
X35 X a_120_21# VPWR VPB abpmos
X36 X a_120_21# VPWR VPB abpmos
X37 a_496_49# a_919_297# a_1023_365# VPB abpmos
X38 a_496_49# a_919_297# a_1023_365# VPB abpmos
X39 a_1290_49# a_1023_365# VGND VNB abnmos
X40 a_1290_49# a_1023_365# VGND VNB abnmos
X41 X a_120_21# VPWR VPB abpmos
X42 X a_120_21# VPWR VPB abpmos
X43 X a_120_21# VPWR VPB abpmos
X44 a_478_325# a_919_297# a_1290_49# VPB abpmos
X45 a_478_325# a_919_297# a_1290_49# VPB abpmos
X46 a_120_21# a_358_93# a_478_325# VNB abnmos
X47 a_120_21# a_358_93# a_478_325# VNB abnmos
X48 a_1023_365# A VPWR VPB abpmos
X49 a_1023_365# A VPWR VPB abpmos
X50 a_1023_365# A VPWR VPB abpmos
.ends XOR3D2B
