* HAD4 : abstract conversion of sky130_fd_sc_hd__ha_4
* 90 abstract devices (width -> parallel min-width fingers)
.subckt HAD4 A B VGND VPWR COUT SUM
XHAD4B A B VGND VGND VPWR VPWR COUT SUM HAD4B
.ends HAD4

.subckt HAD4B A B VGND VNB VPB VPWR COUT SUM
X0 COUT a_514_199# VGND VNB abnmos
X1 COUT a_514_199# VGND VNB abnmos
X2 a_890_297# A VPWR VPB abpmos
X3 a_890_297# A VPWR VPB abpmos
X4 a_890_297# A VPWR VPB abpmos
X5 a_514_199# B VPWR VPB abpmos
X6 a_514_199# B VPWR VPB abpmos
X7 a_514_199# B VPWR VPB abpmos
X8 a_717_297# B a_79_21# VPB abpmos
X9 a_717_297# B a_79_21# VPB abpmos
X10 a_717_297# B a_79_21# VPB abpmos
X11 a_79_21# a_514_199# a_467_47# VNB abnmos
X12 a_79_21# a_514_199# a_467_47# VNB abnmos
X13 SUM a_79_21# VGND VNB abnmos
X14 SUM a_79_21# VGND VNB abnmos
X15 a_1167_47# B a_514_199# VNB abnmos
X16 a_1167_47# B a_514_199# VNB abnmos
X17 COUT a_514_199# VGND VNB abnmos
X18 COUT a_514_199# VGND VNB abnmos
X19 a_79_21# B a_890_297# VPB abpmos
X20 a_79_21# B a_890_297# VPB abpmos
X21 a_79_21# B a_890_297# VPB abpmos
X22 a_467_47# B VGND VNB abnmos
X23 a_467_47# B VGND VNB abnmos
X24 a_79_21# a_514_199# VPWR VPB abpmos
X25 a_79_21# a_514_199# VPWR VPB abpmos
X26 a_79_21# a_514_199# VPWR VPB abpmos
X27 a_514_199# A VPWR VPB abpmos
X28 a_514_199# A VPWR VPB abpmos
X29 a_514_199# A VPWR VPB abpmos
X30 a_1167_47# A VGND VNB abnmos
X31 a_1167_47# A VGND VNB abnmos
X32 a_1325_47# A VGND VNB abnmos
X33 a_1325_47# A VGND VNB abnmos
X34 a_514_199# B VPWR VPB abpmos
X35 a_514_199# B VPWR VPB abpmos
X36 a_514_199# B VPWR VPB abpmos
X37 a_467_47# A VGND VNB abnmos
X38 a_467_47# A VGND VNB abnmos
X39 a_467_47# A VGND VNB abnmos
X40 a_467_47# A VGND VNB abnmos
X41 a_514_199# B a_1325_47# VNB abnmos
X42 a_514_199# B a_1325_47# VNB abnmos
X43 SUM a_79_21# VGND VNB abnmos
X44 SUM a_79_21# VGND VNB abnmos
X45 a_467_47# a_514_199# a_79_21# VNB abnmos
X46 a_467_47# a_514_199# a_79_21# VNB abnmos
X47 COUT a_514_199# VGND VNB abnmos
X48 COUT a_514_199# VGND VNB abnmos
X49 COUT a_514_199# VPWR VPB abpmos
X50 COUT a_514_199# VPWR VPB abpmos
X51 COUT a_514_199# VPWR VPB abpmos
X52 COUT a_514_199# VPWR VPB abpmos
X53 COUT a_514_199# VPWR VPB abpmos
X54 COUT a_514_199# VPWR VPB abpmos
X55 a_467_47# B VGND VNB abnmos
X56 a_467_47# B VGND VNB abnmos
X57 COUT a_514_199# VGND VNB abnmos
X58 COUT a_514_199# VGND VNB abnmos
X59 SUM a_79_21# VGND VNB abnmos
X60 SUM a_79_21# VGND VNB abnmos
X61 SUM a_79_21# VPWR VPB abpmos
X62 SUM a_79_21# VPWR VPB abpmos
X63 SUM a_79_21# VPWR VPB abpmos
X64 a_717_297# A VPWR VPB abpmos
X65 a_717_297# A VPWR VPB abpmos
X66 a_717_297# A VPWR VPB abpmos
X67 SUM a_79_21# VGND VNB abnmos
X68 SUM a_79_21# VGND VNB abnmos
X69 COUT a_514_199# VPWR VPB abpmos
X70 COUT a_514_199# VPWR VPB abpmos
X71 COUT a_514_199# VPWR VPB abpmos
X72 COUT a_514_199# VPWR VPB abpmos
X73 COUT a_514_199# VPWR VPB abpmos
X74 COUT a_514_199# VPWR VPB abpmos
X75 SUM a_79_21# VPWR VPB abpmos
X76 SUM a_79_21# VPWR VPB abpmos
X77 SUM a_79_21# VPWR VPB abpmos
X78 SUM a_79_21# VPWR VPB abpmos
X79 SUM a_79_21# VPWR VPB abpmos
X80 SUM a_79_21# VPWR VPB abpmos
X81 SUM a_79_21# VPWR VPB abpmos
X82 SUM a_79_21# VPWR VPB abpmos
X83 SUM a_79_21# VPWR VPB abpmos
X84 a_79_21# a_514_199# VPWR VPB abpmos
X85 a_79_21# a_514_199# VPWR VPB abpmos
X86 a_79_21# a_514_199# VPWR VPB abpmos
X87 a_514_199# A VPWR VPB abpmos
X88 a_514_199# A VPWR VPB abpmos
X89 a_514_199# A VPWR VPB abpmos
.ends HAD4B
