* O311AID4 : abstract conversion of sky130_fd_sc_hd__o311ai_4
* 100 abstract devices (width -> parallel min-width fingers)
.subckt O311AID4 A1 A2 A3 B1 C1 VGND VPWR Y
XO311AID4B A1 A2 A3 B1 C1 VGND VGND VPWR VPWR Y O311AID4B
.ends O311AID4

.subckt O311AID4B A1 A2 A3 B1 C1 VGND VNB VPB VPWR Y
X0 a_39_297# A1 VPWR VPB abpmos
X1 a_39_297# A1 VPWR VPB abpmos
X2 a_39_297# A1 VPWR VPB abpmos
X3 a_125_47# A3 VGND VNB abnmos
X4 a_125_47# A3 VGND VNB abnmos
X5 a_461_297# A2 a_39_297# VPB abpmos
X6 a_461_297# A2 a_39_297# VPB abpmos
X7 a_461_297# A2 a_39_297# VPB abpmos
X8 a_461_297# A3 Y VPB abpmos
X9 a_461_297# A3 Y VPB abpmos
X10 a_461_297# A3 Y VPB abpmos
X11 a_125_47# A2 VGND VNB abnmos
X12 a_125_47# A2 VGND VNB abnmos
X13 a_125_47# A3 VGND VNB abnmos
X14 a_125_47# A3 VGND VNB abnmos
X15 a_39_297# A1 VPWR VPB abpmos
X16 a_39_297# A1 VPWR VPB abpmos
X17 a_39_297# A1 VPWR VPB abpmos
X18 Y B1 VPWR VPB abpmos
X19 Y B1 VPWR VPB abpmos
X20 Y B1 VPWR VPB abpmos
X21 a_39_297# A2 a_461_297# VPB abpmos
X22 a_39_297# A2 a_461_297# VPB abpmos
X23 a_39_297# A2 a_461_297# VPB abpmos
X24 Y A3 a_461_297# VPB abpmos
X25 Y A3 a_461_297# VPB abpmos
X26 Y A3 a_461_297# VPB abpmos
X27 a_125_47# A3 VGND VNB abnmos
X28 a_125_47# A3 VGND VNB abnmos
X29 Y C1 a_1163_47# VNB abnmos
X30 Y C1 a_1163_47# VNB abnmos
X31 a_39_297# A1 VPWR VPB abpmos
X32 a_39_297# A1 VPWR VPB abpmos
X33 a_39_297# A1 VPWR VPB abpmos
X34 a_125_47# A1 VGND VNB abnmos
X35 a_125_47# A1 VGND VNB abnmos
X36 a_1163_47# C1 Y VNB abnmos
X37 a_1163_47# C1 Y VNB abnmos
X38 Y B1 VPWR VPB abpmos
X39 Y B1 VPWR VPB abpmos
X40 Y B1 VPWR VPB abpmos
X41 a_125_47# A1 VGND VNB abnmos
X42 a_125_47# A1 VGND VNB abnmos
X43 a_39_297# A2 a_461_297# VPB abpmos
X44 a_39_297# A2 a_461_297# VPB abpmos
X45 a_39_297# A2 a_461_297# VPB abpmos
X46 Y C1 VPWR VPB abpmos
X47 Y C1 VPWR VPB abpmos
X48 Y C1 VPWR VPB abpmos
X49 a_125_47# B1 a_1163_47# VNB abnmos
X50 a_125_47# B1 a_1163_47# VNB abnmos
X51 Y C1 VPWR VPB abpmos
X52 Y C1 VPWR VPB abpmos
X53 Y C1 VPWR VPB abpmos
X54 Y B1 VPWR VPB abpmos
X55 Y B1 VPWR VPB abpmos
X56 Y B1 VPWR VPB abpmos
X57 a_125_47# B1 a_1163_47# VNB abnmos
X58 a_125_47# B1 a_1163_47# VNB abnmos
X59 Y B1 VPWR VPB abpmos
X60 Y B1 VPWR VPB abpmos
X61 Y B1 VPWR VPB abpmos
X62 a_461_297# A2 a_39_297# VPB abpmos
X63 a_461_297# A2 a_39_297# VPB abpmos
X64 a_461_297# A2 a_39_297# VPB abpmos
X65 a_125_47# A1 VGND VNB abnmos
X66 a_125_47# A1 VGND VNB abnmos
X67 Y A3 a_461_297# VPB abpmos
X68 Y A3 a_461_297# VPB abpmos
X69 Y A3 a_461_297# VPB abpmos
X70 Y C1 VPWR VPB abpmos
X71 Y C1 VPWR VPB abpmos
X72 Y C1 VPWR VPB abpmos
X73 Y C1 a_1163_47# VNB abnmos
X74 Y C1 a_1163_47# VNB abnmos
X75 a_125_47# A2 VGND VNB abnmos
X76 a_125_47# A2 VGND VNB abnmos
X77 a_125_47# A1 VGND VNB abnmos
X78 a_125_47# A1 VGND VNB abnmos
X79 a_125_47# A2 VGND VNB abnmos
X80 a_125_47# A2 VGND VNB abnmos
X81 a_461_297# A3 Y VPB abpmos
X82 a_461_297# A3 Y VPB abpmos
X83 a_461_297# A3 Y VPB abpmos
X84 Y C1 VPWR VPB abpmos
X85 Y C1 VPWR VPB abpmos
X86 Y C1 VPWR VPB abpmos
X87 a_1163_47# B1 a_125_47# VNB abnmos
X88 a_1163_47# B1 a_125_47# VNB abnmos
X89 a_1163_47# C1 Y VNB abnmos
X90 a_1163_47# C1 Y VNB abnmos
X91 a_1163_47# B1 a_125_47# VNB abnmos
X92 a_1163_47# B1 a_125_47# VNB abnmos
X93 a_125_47# A2 VGND VNB abnmos
X94 a_125_47# A2 VGND VNB abnmos
X95 a_125_47# A3 VGND VNB abnmos
X96 a_125_47# A3 VGND VNB abnmos
X97 a_39_297# A1 VPWR VPB abpmos
X98 a_39_297# A1 VPWR VPB abpmos
X99 a_39_297# A1 VPWR VPB abpmos
.ends O311AID4B
