* auto-generated runcell for LPFLOW_INPUTISOLATCHD1
.lib "$SPICE_LIB/sky130.lib.spice" tt
.include "$SPICE_DEVICES/devices.cir"
.include "lpflow_inputisolatchd1.cir"

.param pvdd=1.8V
VVPWR VDD 0 {pvdd}
V_GND VGND 0 0

V_D D 0 PWL( 0ns 0 10ns 0 10.1ns {pvdd} 20ns {pvdd} 20.1ns 0 30ns 0 30.1ns {pvdd} 40ns {pvdd} )
V_SLEEP_B SLEEP_B 0 PWL( 0ns 0 20ns 0 20.1ns {pvdd} 40ns {pvdd} )

X1 D SLEEP_B VGND VDD Q LPFLOW_INPUTISOLATCHD1
CL_Q Q VGND 0.1f

.control
tran 0.05n 40n
wrdata result.raw v(D) v(SLEEP_B) v(Q)
.endc
.end
