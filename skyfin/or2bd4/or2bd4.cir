* OR2BD4 : abstract conversion of sky130_fd_sc_hd__or2b_4
* 32 abstract devices (width -> parallel min-width fingers)
.subckt OR2BD4 A B_N VGND VPWR X
XOR2BD4B A B_N VGND VGND VPWR VPWR X OR2BD4B
.ends OR2BD4

.subckt OR2BD4B A B_N VGND VNB VPB VPWR X
X0 X a_219_297# VPWR VPB abpmos
X1 X a_219_297# VPWR VPB abpmos
X2 X a_219_297# VPWR VPB abpmos
X3 a_219_297# A VGND VNB abnmos
X4 a_219_297# A VGND VNB abnmos
X5 X a_219_297# VGND VNB abnmos
X6 X a_219_297# VGND VNB abnmos
X7 X a_219_297# VGND VNB abnmos
X8 X a_219_297# VGND VNB abnmos
X9 a_27_53# B_N VGND VNB abnmos
X10 X a_219_297# VGND VNB abnmos
X11 X a_219_297# VGND VNB abnmos
X12 a_27_53# B_N VPWR VPB abpmos
X13 X a_219_297# VPWR VPB abpmos
X14 X a_219_297# VPWR VPB abpmos
X15 X a_219_297# VPWR VPB abpmos
X16 X a_219_297# VGND VNB abnmos
X17 X a_219_297# VGND VNB abnmos
X18 a_219_297# a_27_53# a_301_297# VPB abpmos
X19 a_219_297# a_27_53# a_301_297# VPB abpmos
X20 a_219_297# a_27_53# a_301_297# VPB abpmos
X21 a_301_297# A VPWR VPB abpmos
X22 a_301_297# A VPWR VPB abpmos
X23 a_301_297# A VPWR VPB abpmos
X24 a_219_297# a_27_53# VGND VNB abnmos
X25 a_219_297# a_27_53# VGND VNB abnmos
X26 X a_219_297# VPWR VPB abpmos
X27 X a_219_297# VPWR VPB abpmos
X28 X a_219_297# VPWR VPB abpmos
X29 X a_219_297# VPWR VPB abpmos
X30 X a_219_297# VPWR VPB abpmos
X31 X a_219_297# VPWR VPB abpmos
.ends OR2BD4B
