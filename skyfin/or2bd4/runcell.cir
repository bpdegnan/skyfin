* auto-generated runcell for OR2BD4
.lib "$SPICE_LIB/sky130.lib.spice" tt
.include "$SPICE_DEVICES/devices.cir"
.include "or2bd4.cir"

.param pvdd=1.8V
VVPWR VDD 0 {pvdd}
V_GND VGND 0 0

V_A A 0 PWL( 0ns 0 10ns 0 10.1ns {pvdd} 20ns {pvdd} 20.1ns 0 30ns 0 30.1ns {pvdd} 40ns {pvdd} )
V_B_N B_N 0 PWL( 0ns 0 20ns 0 20.1ns {pvdd} 40ns {pvdd} )

X1 A B_N VGND VDD X OR2BD4
CL_X X VGND 0.1f

.control
tran 0.05n 40n
wrdata result.raw v(A) v(B_N) v(X)
.endc
.end
