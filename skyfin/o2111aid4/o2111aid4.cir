* O2111AID4 : abstract conversion of sky130_fd_sc_hd__o2111ai_4
* 100 abstract devices (width -> parallel min-width fingers)
.subckt O2111AID4 A1 A2 B1 C1 D1 VGND VPWR Y
XO2111AID4B A1 A2 B1 C1 D1 VGND VGND VPWR VPWR Y O2111AID4B
.ends O2111AID4

.subckt O2111AID4B A1 A2 B1 C1 D1 VGND VNB VPB VPWR Y
X0 a_803_47# B1 a_445_47# VNB abnmos
X1 a_803_47# B1 a_445_47# VNB abnmos
X2 a_27_47# C1 a_445_47# VNB abnmos
X3 a_27_47# C1 a_445_47# VNB abnmos
X4 a_27_47# C1 a_445_47# VNB abnmos
X5 a_27_47# C1 a_445_47# VNB abnmos
X6 a_803_47# B1 a_445_47# VNB abnmos
X7 a_803_47# B1 a_445_47# VNB abnmos
X8 Y B1 VPWR VPB abpmos
X9 Y B1 VPWR VPB abpmos
X10 Y B1 VPWR VPB abpmos
X11 Y C1 VPWR VPB abpmos
X12 Y C1 VPWR VPB abpmos
X13 Y C1 VPWR VPB abpmos
X14 a_1163_297# A1 VPWR VPB abpmos
X15 a_1163_297# A1 VPWR VPB abpmos
X16 a_1163_297# A1 VPWR VPB abpmos
X17 a_803_47# A2 VGND VNB abnmos
X18 a_803_47# A2 VGND VNB abnmos
X19 Y C1 VPWR VPB abpmos
X20 Y C1 VPWR VPB abpmos
X21 Y C1 VPWR VPB abpmos
X22 Y D1 a_27_47# VNB abnmos
X23 Y D1 a_27_47# VNB abnmos
X24 a_1163_297# A1 VPWR VPB abpmos
X25 a_1163_297# A1 VPWR VPB abpmos
X26 a_1163_297# A1 VPWR VPB abpmos
X27 Y C1 VPWR VPB abpmos
X28 Y C1 VPWR VPB abpmos
X29 Y C1 VPWR VPB abpmos
X30 a_1163_297# A1 VPWR VPB abpmos
X31 a_1163_297# A1 VPWR VPB abpmos
X32 a_1163_297# A1 VPWR VPB abpmos
X33 Y B1 VPWR VPB abpmos
X34 Y B1 VPWR VPB abpmos
X35 Y B1 VPWR VPB abpmos
X36 a_445_47# C1 a_27_47# VNB abnmos
X37 a_445_47# C1 a_27_47# VNB abnmos
X38 a_1163_297# A2 Y VPB abpmos
X39 a_1163_297# A2 Y VPB abpmos
X40 a_1163_297# A2 Y VPB abpmos
X41 a_803_47# A1 VGND VNB abnmos
X42 a_803_47# A1 VGND VNB abnmos
X43 a_1163_297# A1 VPWR VPB abpmos
X44 a_1163_297# A1 VPWR VPB abpmos
X45 a_1163_297# A1 VPWR VPB abpmos
X46 Y B1 VPWR VPB abpmos
X47 Y B1 VPWR VPB abpmos
X48 Y B1 VPWR VPB abpmos
X49 a_803_47# A2 VGND VNB abnmos
X50 a_803_47# A2 VGND VNB abnmos
X51 a_803_47# A1 VGND VNB abnmos
X52 a_803_47# A1 VGND VNB abnmos
X53 Y A2 a_1163_297# VPB abpmos
X54 Y A2 a_1163_297# VPB abpmos
X55 Y A2 a_1163_297# VPB abpmos
X56 a_803_47# A1 VGND VNB abnmos
X57 a_803_47# A1 VGND VNB abnmos
X58 Y B1 VPWR VPB abpmos
X59 Y B1 VPWR VPB abpmos
X60 Y B1 VPWR VPB abpmos
X61 a_27_47# D1 Y VNB abnmos
X62 a_27_47# D1 Y VNB abnmos
X63 a_803_47# A2 VGND VNB abnmos
X64 a_803_47# A2 VGND VNB abnmos
X65 Y A2 a_1163_297# VPB abpmos
X66 Y A2 a_1163_297# VPB abpmos
X67 Y A2 a_1163_297# VPB abpmos
X68 a_803_47# A1 VGND VNB abnmos
X69 a_803_47# A1 VGND VNB abnmos
X70 Y D1 a_27_47# VNB abnmos
X71 Y D1 a_27_47# VNB abnmos
X72 Y D1 VPWR VPB abpmos
X73 Y D1 VPWR VPB abpmos
X74 Y D1 VPWR VPB abpmos
X75 a_27_47# D1 Y VNB abnmos
X76 a_27_47# D1 Y VNB abnmos
X77 Y C1 VPWR VPB abpmos
X78 Y C1 VPWR VPB abpmos
X79 Y C1 VPWR VPB abpmos
X80 Y D1 VPWR VPB abpmos
X81 Y D1 VPWR VPB abpmos
X82 Y D1 VPWR VPB abpmos
X83 Y D1 VPWR VPB abpmos
X84 Y D1 VPWR VPB abpmos
X85 Y D1 VPWR VPB abpmos
X86 a_445_47# B1 a_803_47# VNB abnmos
X87 a_445_47# B1 a_803_47# VNB abnmos
X88 a_803_47# A2 VGND VNB abnmos
X89 a_803_47# A2 VGND VNB abnmos
X90 a_445_47# C1 a_27_47# VNB abnmos
X91 a_445_47# C1 a_27_47# VNB abnmos
X92 Y D1 VPWR VPB abpmos
X93 Y D1 VPWR VPB abpmos
X94 Y D1 VPWR VPB abpmos
X95 a_1163_297# A2 Y VPB abpmos
X96 a_1163_297# A2 Y VPB abpmos
X97 a_1163_297# A2 Y VPB abpmos
X98 a_445_47# B1 a_803_47# VNB abnmos
X99 a_445_47# B1 a_803_47# VNB abnmos
.ends O2111AID4B
