* XNOR2D4 : abstract conversion of sky130_fd_sc_hd__xnor2_4
* 100 abstract devices (width -> parallel min-width fingers)
.subckt XNOR2D4 A B VGND VPWR Y
XXNOR2D4B A B VGND VGND VPWR VPWR Y XNOR2D4B
.ends XNOR2D4

.subckt XNOR2D4B A B VGND VNB VPB VPWR Y
X0 a_38_47# A VGND VNB abnmos
X1 a_38_47# A VGND VNB abnmos
X2 a_38_297# B a_38_47# VNB abnmos
X3 a_38_297# B a_38_47# VNB abnmos
X4 a_38_47# A VGND VNB abnmos
X5 a_38_47# A VGND VNB abnmos
X6 a_38_297# B VPWR VPB abpmos
X7 a_38_297# B VPWR VPB abpmos
X8 a_38_297# B VPWR VPB abpmos
X9 a_820_297# A VPWR VPB abpmos
X10 a_820_297# A VPWR VPB abpmos
X11 a_820_297# A VPWR VPB abpmos
X12 Y a_38_297# VPWR VPB abpmos
X13 Y a_38_297# VPWR VPB abpmos
X14 Y a_38_297# VPWR VPB abpmos
X15 a_38_297# A VPWR VPB abpmos
X16 a_38_297# A VPWR VPB abpmos
X17 a_38_297# A VPWR VPB abpmos
X18 Y a_38_297# VPWR VPB abpmos
X19 Y a_38_297# VPWR VPB abpmos
X20 Y a_38_297# VPWR VPB abpmos
X21 a_38_297# B VPWR VPB abpmos
X22 a_38_297# B VPWR VPB abpmos
X23 a_38_297# B VPWR VPB abpmos
X24 a_820_297# A VPWR VPB abpmos
X25 a_820_297# A VPWR VPB abpmos
X26 a_820_297# A VPWR VPB abpmos
X27 Y a_38_297# VPWR VPB abpmos
X28 Y a_38_297# VPWR VPB abpmos
X29 Y a_38_297# VPWR VPB abpmos
X30 a_38_47# A VGND VNB abnmos
X31 a_38_47# A VGND VNB abnmos
X32 a_820_297# B Y VPB abpmos
X33 a_820_297# B Y VPB abpmos
X34 a_820_297# B Y VPB abpmos
X35 Y a_38_297# VPWR VPB abpmos
X36 Y a_38_297# VPWR VPB abpmos
X37 Y a_38_297# VPWR VPB abpmos
X38 Y a_38_297# a_902_47# VNB abnmos
X39 Y a_38_297# a_902_47# VNB abnmos
X40 a_902_47# B VGND VNB abnmos
X41 a_902_47# B VGND VNB abnmos
X42 a_38_297# A VPWR VPB abpmos
X43 a_38_297# A VPWR VPB abpmos
X44 a_38_297# A VPWR VPB abpmos
X45 Y B a_820_297# VPB abpmos
X46 Y B a_820_297# VPB abpmos
X47 Y B a_820_297# VPB abpmos
X48 a_38_47# A VGND VNB abnmos
X49 a_38_47# A VGND VNB abnmos
X50 a_902_47# B VGND VNB abnmos
X51 a_902_47# B VGND VNB abnmos
X52 a_902_47# a_38_297# Y VNB abnmos
X53 a_902_47# a_38_297# Y VNB abnmos
X54 Y B a_820_297# VPB abpmos
X55 Y B a_820_297# VPB abpmos
X56 Y B a_820_297# VPB abpmos
X57 a_902_47# A VGND VNB abnmos
X58 a_902_47# A VGND VNB abnmos
X59 a_902_47# B VGND VNB abnmos
X60 a_902_47# B VGND VNB abnmos
X61 a_902_47# A VGND VNB abnmos
X62 a_902_47# A VGND VNB abnmos
X63 a_38_297# A VPWR VPB abpmos
X64 a_38_297# A VPWR VPB abpmos
X65 a_38_297# A VPWR VPB abpmos
X66 a_38_297# B a_38_47# VNB abnmos
X67 a_38_297# B a_38_47# VNB abnmos
X68 a_902_47# A VGND VNB abnmos
X69 a_902_47# A VGND VNB abnmos
X70 a_902_47# A VGND VNB abnmos
X71 a_902_47# A VGND VNB abnmos
X72 a_820_297# B Y VPB abpmos
X73 a_820_297# B Y VPB abpmos
X74 a_820_297# B Y VPB abpmos
X75 a_38_47# B a_38_297# VNB abnmos
X76 a_38_47# B a_38_297# VNB abnmos
X77 Y a_38_297# a_902_47# VNB abnmos
X78 Y a_38_297# a_902_47# VNB abnmos
X79 a_820_297# A VPWR VPB abpmos
X80 a_820_297# A VPWR VPB abpmos
X81 a_820_297# A VPWR VPB abpmos
X82 a_902_47# a_38_297# Y VNB abnmos
X83 a_902_47# a_38_297# Y VNB abnmos
X84 a_38_47# B a_38_297# VNB abnmos
X85 a_38_47# B a_38_297# VNB abnmos
X86 a_38_297# B VPWR VPB abpmos
X87 a_38_297# B VPWR VPB abpmos
X88 a_38_297# B VPWR VPB abpmos
X89 a_902_47# B VGND VNB abnmos
X90 a_902_47# B VGND VNB abnmos
X91 a_38_297# B VPWR VPB abpmos
X92 a_38_297# B VPWR VPB abpmos
X93 a_38_297# B VPWR VPB abpmos
X94 a_820_297# A VPWR VPB abpmos
X95 a_820_297# A VPWR VPB abpmos
X96 a_820_297# A VPWR VPB abpmos
X97 a_38_297# A VPWR VPB abpmos
X98 a_38_297# A VPWR VPB abpmos
X99 a_38_297# A VPWR VPB abpmos
.ends XNOR2D4B
