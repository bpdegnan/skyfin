* auto-generated runcell for NAND2D8
.lib "$SPICE_LIB/sky130.lib.spice" tt
.include "$SPICE_DEVICES/devices.cir"
.include "nand2d8.cir"

.param pvdd=1.8V
VVPWR VDD 0 {pvdd}
V_GND VGND 0 0

V_A A 0 PWL( 0ns 0 10ns 0 10.1ns {pvdd} 20ns {pvdd} 20.1ns 0 30ns 0 30.1ns {pvdd} 40ns {pvdd} )
V_B B 0 PWL( 0ns 0 20ns 0 20.1ns {pvdd} 40ns {pvdd} )

X1 A B VGND VDD Y NAND2D8
CL_Y Y VGND 0.1f

.control
tran 0.05n 40n
wrdata result.raw v(A) v(B) v(Y)
.endc
.end
