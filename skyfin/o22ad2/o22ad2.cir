* O22AD2 : abstract conversion of sky130_fd_sc_hd__o22a_2
* 30 abstract devices (width -> parallel min-width fingers)
.subckt O22AD2 A1 A2 B1 B2 VGND VPWR X
XO22AD2B A1 A2 B1 B2 VGND VGND VPWR VPWR X O22AD2B
.ends O22AD2

.subckt O22AD2B A1 A2 B1 B2 VGND VNB VPB VPWR X
X0 X a_81_21# VPWR VPB abpmos
X1 X a_81_21# VPWR VPB abpmos
X2 X a_81_21# VPWR VPB abpmos
X3 a_81_21# B2 a_301_47# VNB abnmos
X4 a_81_21# B2 a_301_47# VNB abnmos
X5 X a_81_21# VGND VNB abnmos
X6 X a_81_21# VGND VNB abnmos
X7 a_301_47# B1 a_81_21# VNB abnmos
X8 a_301_47# B1 a_81_21# VNB abnmos
X9 X a_81_21# VPWR VPB abpmos
X10 X a_81_21# VPWR VPB abpmos
X11 X a_81_21# VPWR VPB abpmos
X12 a_81_21# A2 a_579_297# VPB abpmos
X13 a_81_21# A2 a_579_297# VPB abpmos
X14 a_81_21# A2 a_579_297# VPB abpmos
X15 a_383_297# B1 VPWR VPB abpmos
X16 a_383_297# B1 VPWR VPB abpmos
X17 a_383_297# B1 VPWR VPB abpmos
X18 a_383_297# B2 a_81_21# VPB abpmos
X19 a_383_297# B2 a_81_21# VPB abpmos
X20 a_383_297# B2 a_81_21# VPB abpmos
X21 a_301_47# A1 VGND VNB abnmos
X22 a_301_47# A1 VGND VNB abnmos
X23 a_301_47# A2 VGND VNB abnmos
X24 a_301_47# A2 VGND VNB abnmos
X25 a_579_297# A1 VPWR VPB abpmos
X26 a_579_297# A1 VPWR VPB abpmos
X27 a_579_297# A1 VPWR VPB abpmos
X28 X a_81_21# VGND VNB abnmos
X29 X a_81_21# VGND VNB abnmos
.ends O22AD2B
