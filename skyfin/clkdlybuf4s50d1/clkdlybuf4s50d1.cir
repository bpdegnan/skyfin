* CLKDLYBUF4S50D1 : abstract conversion of sky130_fd_sc_hd__clkdlybuf4s50_1
* 16 abstract devices (width -> parallel min-width fingers)
.subckt CLKDLYBUF4S50D1 A VGND VPWR X
XCLKDLYBUF4S50D1B A VGND VGND VPWR VPWR X CLKDLYBUF4S50D1B
.ends CLKDLYBUF4S50D1

.subckt CLKDLYBUF4S50D1B A VGND VNB VPB VPWR X
X0 a_390_47# a_283_47# VGND VNB abnmos
X1 a_390_47# a_283_47# VGND VNB abnmos
X2 a_27_47# A VPWR VPB abpmos
X3 a_27_47# A VPWR VPB abpmos
X4 a_27_47# A VPWR VPB abpmos
X5 a_283_47# a_27_47# VPWR VPB abpmos
X6 a_283_47# a_27_47# VPWR VPB abpmos
X7 a_283_47# a_27_47# VGND VNB abnmos
X8 a_283_47# a_27_47# VGND VNB abnmos
X9 X a_390_47# VPWR VPB abpmos
X10 X a_390_47# VPWR VPB abpmos
X11 X a_390_47# VPWR VPB abpmos
X12 X a_390_47# VGND VNB abnmos
X13 a_390_47# a_283_47# VPWR VPB abpmos
X14 a_390_47# a_283_47# VPWR VPB abpmos
X15 a_27_47# A VGND VNB abnmos
.ends CLKDLYBUF4S50D1B
