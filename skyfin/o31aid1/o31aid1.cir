* O31AID1 : abstract conversion of sky130_fd_sc_hd__o31ai_1
* 20 abstract devices (width -> parallel min-width fingers)
.subckt O31AID1 A1 A2 A3 B1 VGND VPWR Y
XO31AID1B A1 A2 A3 B1 VGND VGND VPWR VPWR Y O31AID1B
.ends O31AID1

.subckt O31AID1B A1 A2 A3 B1 VGND VNB VPB VPWR Y
X0 Y B1 VPWR VPB abpmos
X1 Y B1 VPWR VPB abpmos
X2 Y B1 VPWR VPB abpmos
X3 a_109_47# A3 VGND VNB abnmos
X4 a_109_47# A3 VGND VNB abnmos
X5 a_109_47# A2 VGND VNB abnmos
X6 a_109_47# A2 VGND VNB abnmos
X7 a_109_47# B1 Y VNB abnmos
X8 a_109_47# B1 Y VNB abnmos
X9 a_193_297# A3 Y VPB abpmos
X10 a_193_297# A3 Y VPB abpmos
X11 a_193_297# A3 Y VPB abpmos
X12 a_109_47# A1 VGND VNB abnmos
X13 a_109_47# A1 VGND VNB abnmos
X14 a_109_297# A1 VPWR VPB abpmos
X15 a_109_297# A1 VPWR VPB abpmos
X16 a_109_297# A1 VPWR VPB abpmos
X17 a_109_297# A2 a_193_297# VPB abpmos
X18 a_109_297# A2 a_193_297# VPB abpmos
X19 a_109_297# A2 a_193_297# VPB abpmos
.ends O31AID1B
