* DLXBND2 : abstract conversion of sky130_fd_sc_hd__dlxbn_2
* 46 abstract devices (width -> parallel min-width fingers)
.subckt DLXBND2 D GATE_N VGND VPWR Q Q_N
XDLXBND2B D GATE_N VGND VGND VPWR VPWR Q Q_N DLXBND2B
.ends DLXBND2

.subckt DLXBND2B D GATE_N VGND VNB VPB VPWR Q Q_N
X0 Q a_728_21# VPWR VPB abpmos
X1 Q a_728_21# VPWR VPB abpmos
X2 Q a_728_21# VPWR VPB abpmos
X3 a_663_47# a_728_21# VGND VNB abnmos
X4 Q_N a_1223_47# VGND VNB abnmos
X5 Q_N a_1223_47# VGND VNB abnmos
X6 a_728_21# a_565_413# VGND VNB abnmos
X7 a_728_21# a_565_413# VGND VNB abnmos
X8 a_565_413# a_27_47# a_686_413# VPB abpmos
X9 a_686_413# a_728_21# VPWR VPB abpmos
X10 a_469_369# a_303_47# VPWR VPB abpmos
X11 a_469_369# a_303_47# VPWR VPB abpmos
X12 a_469_369# a_193_47# a_565_413# VPB abpmos
X13 Q a_728_21# VPWR VPB abpmos
X14 Q a_728_21# VPWR VPB abpmos
X15 Q a_728_21# VPWR VPB abpmos
X16 a_303_47# D VPWR VPB abpmos
X17 a_303_47# D VPWR VPB abpmos
X18 Q a_728_21# VGND VNB abnmos
X19 Q a_728_21# VGND VNB abnmos
X20 a_469_47# a_303_47# VGND VNB abnmos
X21 a_469_47# a_27_47# a_565_413# VNB abnmos
X22 a_565_413# a_193_47# a_663_47# VNB abnmos
X23 Q_N a_1223_47# VGND VNB abnmos
X24 Q_N a_1223_47# VGND VNB abnmos
X25 a_303_47# D VGND VNB abnmos
X26 a_193_47# a_27_47# VGND VNB abnmos
X27 a_27_47# GATE_N VGND VNB abnmos
X28 a_27_47# GATE_N VPWR VPB abpmos
X29 a_27_47# GATE_N VPWR VPB abpmos
X30 a_1223_47# a_728_21# VPWR VPB abpmos
X31 a_1223_47# a_728_21# VPWR VPB abpmos
X32 Q a_728_21# VGND VNB abnmos
X33 Q a_728_21# VGND VNB abnmos
X34 a_193_47# a_27_47# VPWR VPB abpmos
X35 a_193_47# a_27_47# VPWR VPB abpmos
X36 Q_N a_1223_47# VPWR VPB abpmos
X37 Q_N a_1223_47# VPWR VPB abpmos
X38 Q_N a_1223_47# VPWR VPB abpmos
X39 a_1223_47# a_728_21# VGND VNB abnmos
X40 Q_N a_1223_47# VPWR VPB abpmos
X41 Q_N a_1223_47# VPWR VPB abpmos
X42 Q_N a_1223_47# VPWR VPB abpmos
X43 a_728_21# a_565_413# VPWR VPB abpmos
X44 a_728_21# a_565_413# VPWR VPB abpmos
X45 a_728_21# a_565_413# VPWR VPB abpmos
.ends DLXBND2B
