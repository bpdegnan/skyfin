* XOR2D1 : abstract conversion of sky130_fd_sc_hd__xor2_1
* 25 abstract devices (width -> parallel min-width fingers)
.subckt XOR2D1 A B VGND VPWR X
XXOR2D1B A B VGND VGND VPWR VPWR X XOR2D1B
.ends XOR2D1

.subckt XOR2D1B A B VGND VNB VPB VPWR X
X0 a_35_297# A VGND VNB abnmos
X1 a_35_297# A VGND VNB abnmos
X2 a_35_297# B VGND VNB abnmos
X3 a_35_297# B VGND VNB abnmos
X4 X a_35_297# VGND VNB abnmos
X5 X a_35_297# VGND VNB abnmos
X6 a_285_297# B VPWR VPB abpmos
X7 a_285_297# B VPWR VPB abpmos
X8 a_285_297# B VPWR VPB abpmos
X9 a_285_297# A VPWR VPB abpmos
X10 a_285_297# A VPWR VPB abpmos
X11 a_285_297# A VPWR VPB abpmos
X12 a_35_297# B a_117_297# VPB abpmos
X13 a_35_297# B a_117_297# VPB abpmos
X14 a_35_297# B a_117_297# VPB abpmos
X15 a_117_297# A VPWR VPB abpmos
X16 a_117_297# A VPWR VPB abpmos
X17 a_117_297# A VPWR VPB abpmos
X18 a_285_47# B X VNB abnmos
X19 a_285_47# B X VNB abnmos
X20 a_285_297# a_35_297# X VPB abpmos
X21 a_285_297# a_35_297# X VPB abpmos
X22 a_285_297# a_35_297# X VPB abpmos
X23 a_285_47# A VGND VNB abnmos
X24 a_285_47# A VGND VNB abnmos
.ends XOR2D1B
