* INVD12 : abstract conversion of sky130_fd_sc_hd__inv_12
* 60 abstract devices (width -> parallel min-width fingers)
.subckt INVD12 A VGND VPWR Y
XINVD12B A VGND VGND VPWR VPWR Y INVD12B
.ends INVD12

.subckt INVD12B A VGND VNB VPB VPWR Y
X0 Y A VGND VNB abnmos
X1 Y A VGND VNB abnmos
X2 Y A VGND VNB abnmos
X3 Y A VGND VNB abnmos
X4 Y A VGND VNB abnmos
X5 Y A VGND VNB abnmos
X6 Y A VPWR VPB abpmos
X7 Y A VPWR VPB abpmos
X8 Y A VPWR VPB abpmos
X9 Y A VGND VNB abnmos
X10 Y A VGND VNB abnmos
X11 Y A VGND VNB abnmos
X12 Y A VGND VNB abnmos
X13 Y A VPWR VPB abpmos
X14 Y A VPWR VPB abpmos
X15 Y A VPWR VPB abpmos
X16 Y A VPWR VPB abpmos
X17 Y A VPWR VPB abpmos
X18 Y A VPWR VPB abpmos
X19 Y A VPWR VPB abpmos
X20 Y A VPWR VPB abpmos
X21 Y A VPWR VPB abpmos
X22 Y A VPWR VPB abpmos
X23 Y A VPWR VPB abpmos
X24 Y A VPWR VPB abpmos
X25 Y A VPWR VPB abpmos
X26 Y A VPWR VPB abpmos
X27 Y A VPWR VPB abpmos
X28 Y A VPWR VPB abpmos
X29 Y A VPWR VPB abpmos
X30 Y A VPWR VPB abpmos
X31 Y A VPWR VPB abpmos
X32 Y A VPWR VPB abpmos
X33 Y A VPWR VPB abpmos
X34 Y A VGND VNB abnmos
X35 Y A VGND VNB abnmos
X36 Y A VGND VNB abnmos
X37 Y A VGND VNB abnmos
X38 Y A VPWR VPB abpmos
X39 Y A VPWR VPB abpmos
X40 Y A VPWR VPB abpmos
X41 Y A VGND VNB abnmos
X42 Y A VGND VNB abnmos
X43 Y A VGND VNB abnmos
X44 Y A VGND VNB abnmos
X45 Y A VPWR VPB abpmos
X46 Y A VPWR VPB abpmos
X47 Y A VPWR VPB abpmos
X48 Y A VPWR VPB abpmos
X49 Y A VPWR VPB abpmos
X50 Y A VPWR VPB abpmos
X51 Y A VGND VNB abnmos
X52 Y A VGND VNB abnmos
X53 Y A VGND VNB abnmos
X54 Y A VGND VNB abnmos
X55 Y A VGND VNB abnmos
X56 Y A VGND VNB abnmos
X57 Y A VPWR VPB abpmos
X58 Y A VPWR VPB abpmos
X59 Y A VPWR VPB abpmos
.ends INVD12B
