* NOR4D4 : abstract conversion of sky130_fd_sc_hd__nor4_4
* 80 abstract devices (width -> parallel min-width fingers)
.subckt NOR4D4 A B C D VGND VPWR Y
XNOR4D4B A B C D VGND VGND VPWR VPWR Y NOR4D4B
.ends NOR4D4

.subckt NOR4D4B A B C D VGND VNB VPB VPWR Y
X0 a_27_297# B a_449_297# VPB abpmos
X1 a_27_297# B a_449_297# VPB abpmos
X2 a_27_297# B a_449_297# VPB abpmos
X3 a_807_297# C a_449_297# VPB abpmos
X4 a_807_297# C a_449_297# VPB abpmos
X5 a_807_297# C a_449_297# VPB abpmos
X6 Y A VGND VNB abnmos
X7 Y A VGND VNB abnmos
X8 a_27_297# A VPWR VPB abpmos
X9 a_27_297# A VPWR VPB abpmos
X10 a_27_297# A VPWR VPB abpmos
X11 a_27_297# A VPWR VPB abpmos
X12 a_27_297# A VPWR VPB abpmos
X13 a_27_297# A VPWR VPB abpmos
X14 a_449_297# B a_27_297# VPB abpmos
X15 a_449_297# B a_27_297# VPB abpmos
X16 a_449_297# B a_27_297# VPB abpmos
X17 a_449_297# C a_807_297# VPB abpmos
X18 a_449_297# C a_807_297# VPB abpmos
X19 a_449_297# C a_807_297# VPB abpmos
X20 Y D a_807_297# VPB abpmos
X21 Y D a_807_297# VPB abpmos
X22 Y D a_807_297# VPB abpmos
X23 Y A VGND VNB abnmos
X24 Y A VGND VNB abnmos
X25 Y D a_807_297# VPB abpmos
X26 Y D a_807_297# VPB abpmos
X27 Y D a_807_297# VPB abpmos
X28 Y D VGND VNB abnmos
X29 Y D VGND VNB abnmos
X30 a_27_297# A VPWR VPB abpmos
X31 a_27_297# A VPWR VPB abpmos
X32 a_27_297# A VPWR VPB abpmos
X33 a_807_297# D Y VPB abpmos
X34 a_807_297# D Y VPB abpmos
X35 a_807_297# D Y VPB abpmos
X36 a_27_297# A VPWR VPB abpmos
X37 a_27_297# A VPWR VPB abpmos
X38 a_27_297# A VPWR VPB abpmos
X39 a_807_297# D Y VPB abpmos
X40 a_807_297# D Y VPB abpmos
X41 a_807_297# D Y VPB abpmos
X42 Y A VGND VNB abnmos
X43 Y A VGND VNB abnmos
X44 Y D VGND VNB abnmos
X45 Y D VGND VNB abnmos
X46 Y B VGND VNB abnmos
X47 Y B VGND VNB abnmos
X48 Y C VGND VNB abnmos
X49 Y C VGND VNB abnmos
X50 a_27_297# B a_449_297# VPB abpmos
X51 a_27_297# B a_449_297# VPB abpmos
X52 a_27_297# B a_449_297# VPB abpmos
X53 Y A VGND VNB abnmos
X54 Y A VGND VNB abnmos
X55 Y B VGND VNB abnmos
X56 Y B VGND VNB abnmos
X57 Y C VGND VNB abnmos
X58 Y C VGND VNB abnmos
X59 a_449_297# B a_27_297# VPB abpmos
X60 a_449_297# B a_27_297# VPB abpmos
X61 a_449_297# B a_27_297# VPB abpmos
X62 Y D VGND VNB abnmos
X63 Y D VGND VNB abnmos
X64 a_807_297# C a_449_297# VPB abpmos
X65 a_807_297# C a_449_297# VPB abpmos
X66 a_807_297# C a_449_297# VPB abpmos
X67 Y B VGND VNB abnmos
X68 Y B VGND VNB abnmos
X69 Y C VGND VNB abnmos
X70 Y C VGND VNB abnmos
X71 Y D VGND VNB abnmos
X72 Y D VGND VNB abnmos
X73 a_449_297# C a_807_297# VPB abpmos
X74 a_449_297# C a_807_297# VPB abpmos
X75 a_449_297# C a_807_297# VPB abpmos
X76 Y B VGND VNB abnmos
X77 Y B VGND VNB abnmos
X78 Y C VGND VNB abnmos
X79 Y C VGND VNB abnmos
.ends NOR4D4B
