* NOR3D4 : abstract conversion of sky130_fd_sc_hd__nor3_4
* 60 abstract devices (width -> parallel min-width fingers)
.subckt NOR3D4 A B C VGND VPWR Y
XNOR3D4B A B C VGND VGND VPWR VPWR Y NOR3D4B
.ends NOR3D4

.subckt NOR3D4B A B C VGND VNB VPB VPWR Y
X0 a_27_297# B a_449_297# VPB abpmos
X1 a_27_297# B a_449_297# VPB abpmos
X2 a_27_297# B a_449_297# VPB abpmos
X3 Y A VGND VNB abnmos
X4 Y A VGND VNB abnmos
X5 a_27_297# A VPWR VPB abpmos
X6 a_27_297# A VPWR VPB abpmos
X7 a_27_297# A VPWR VPB abpmos
X8 a_27_297# A VPWR VPB abpmos
X9 a_27_297# A VPWR VPB abpmos
X10 a_27_297# A VPWR VPB abpmos
X11 a_449_297# B a_27_297# VPB abpmos
X12 a_449_297# B a_27_297# VPB abpmos
X13 a_449_297# B a_27_297# VPB abpmos
X14 Y A VGND VNB abnmos
X15 Y A VGND VNB abnmos
X16 a_449_297# B a_27_297# VPB abpmos
X17 a_449_297# B a_27_297# VPB abpmos
X18 a_449_297# B a_27_297# VPB abpmos
X19 Y C VGND VNB abnmos
X20 Y C VGND VNB abnmos
X21 a_27_297# A VPWR VPB abpmos
X22 a_27_297# A VPWR VPB abpmos
X23 a_27_297# A VPWR VPB abpmos
X24 Y B VGND VNB abnmos
X25 Y B VGND VNB abnmos
X26 a_27_297# A VPWR VPB abpmos
X27 a_27_297# A VPWR VPB abpmos
X28 a_27_297# A VPWR VPB abpmos
X29 Y A VGND VNB abnmos
X30 Y A VGND VNB abnmos
X31 Y C VGND VNB abnmos
X32 Y C VGND VNB abnmos
X33 a_449_297# C Y VPB abpmos
X34 a_449_297# C Y VPB abpmos
X35 a_449_297# C Y VPB abpmos
X36 Y C VGND VNB abnmos
X37 Y C VGND VNB abnmos
X38 a_27_297# B a_449_297# VPB abpmos
X39 a_27_297# B a_449_297# VPB abpmos
X40 a_27_297# B a_449_297# VPB abpmos
X41 Y A VGND VNB abnmos
X42 Y A VGND VNB abnmos
X43 Y B VGND VNB abnmos
X44 Y B VGND VNB abnmos
X45 Y C a_449_297# VPB abpmos
X46 Y C a_449_297# VPB abpmos
X47 Y C a_449_297# VPB abpmos
X48 Y C a_449_297# VPB abpmos
X49 Y C a_449_297# VPB abpmos
X50 Y C a_449_297# VPB abpmos
X51 a_449_297# C Y VPB abpmos
X52 a_449_297# C Y VPB abpmos
X53 a_449_297# C Y VPB abpmos
X54 Y B VGND VNB abnmos
X55 Y B VGND VNB abnmos
X56 Y C VGND VNB abnmos
X57 Y C VGND VNB abnmos
X58 Y B VGND VNB abnmos
X59 Y B VGND VNB abnmos
.ends NOR3D4B
