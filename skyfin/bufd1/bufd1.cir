* BUFD1 : abstract conversion of sky130_fd_sc_hd__buf_1
* 6 abstract devices (width -> parallel min-width fingers)
.subckt BUFD1 A VGND VPWR X
XBUFD1B A VGND VGND VPWR VPWR X BUFD1B
.ends BUFD1

.subckt BUFD1B A VGND VNB VPB VPWR X
X0 X a_27_47# VGND VNB abnmos
X1 a_27_47# A VPWR VPB abpmos
X2 a_27_47# A VPWR VPB abpmos
X3 a_27_47# A VGND VNB abnmos
X4 X a_27_47# VPWR VPB abpmos
X5 X a_27_47# VPWR VPB abpmos
.ends BUFD1B
