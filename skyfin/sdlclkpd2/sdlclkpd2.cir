* SDLCLKPD2 : abstract conversion of sky130_fd_sc_hd__sdlclkp_2
* 39 abstract devices (width -> parallel min-width fingers)
.subckt SDLCLKPD2 CLK GATE SCE VGND VPWR GCLK
XSDLCLKPD2B CLK GATE SCE VGND VGND VPWR VPWR GCLK SDLCLKPD2B
.ends SDLCLKPD2

.subckt SDLCLKPD2B CLK GATE SCE VGND VNB VPB VPWR GCLK
X0 a_383_413# a_465_315# VPWR VPB abpmos
X1 a_465_315# a_287_413# VGND VNB abnmos
X2 a_465_315# a_287_413# VGND VNB abnmos
X3 a_1102_47# CLK VGND VNB abnmos
X4 a_395_47# a_465_315# VGND VNB abnmos
X5 GCLK a_1020_47# VPWR VPB abpmos
X6 GCLK a_1020_47# VPWR VPB abpmos
X7 GCLK a_1020_47# VPWR VPB abpmos
X8 a_27_47# a_257_147# a_287_413# VNB abnmos
X9 a_1020_47# CLK VPWR VPB abpmos
X10 a_1020_47# CLK VPWR VPB abpmos
X11 a_27_47# a_257_243# a_287_413# VPB abpmos
X12 GCLK a_1020_47# VPWR VPB abpmos
X13 GCLK a_1020_47# VPWR VPB abpmos
X14 GCLK a_1020_47# VPWR VPB abpmos
X15 a_287_413# a_257_147# a_383_413# VPB abpmos
X16 GCLK a_1020_47# VGND VNB abnmos
X17 GCLK a_1020_47# VGND VNB abnmos
X18 a_1020_47# a_465_315# a_1102_47# VNB abnmos
X19 a_287_413# a_257_243# a_395_47# VNB abnmos
X20 a_257_147# CLK VGND VNB abnmos
X21 a_465_315# a_287_413# VPWR VPB abpmos
X22 a_465_315# a_287_413# VPWR VPB abpmos
X23 a_465_315# a_287_413# VPWR VPB abpmos
X24 a_257_243# a_257_147# VGND VNB abnmos
X25 a_109_369# SCE VPWR VPB abpmos
X26 a_109_369# SCE VPWR VPB abpmos
X27 a_257_243# a_257_147# VPWR VPB abpmos
X28 a_257_243# a_257_147# VPWR VPB abpmos
X29 a_257_147# CLK VPWR VPB abpmos
X30 a_257_147# CLK VPWR VPB abpmos
X31 a_27_47# GATE VGND VNB abnmos
X32 GCLK a_1020_47# VGND VNB abnmos
X33 GCLK a_1020_47# VGND VNB abnmos
X34 a_27_47# SCE VGND VNB abnmos
X35 a_109_369# GATE a_27_47# VPB abpmos
X36 a_109_369# GATE a_27_47# VPB abpmos
X37 a_1020_47# a_465_315# VPWR VPB abpmos
X38 a_1020_47# a_465_315# VPWR VPB abpmos
.ends SDLCLKPD2B
