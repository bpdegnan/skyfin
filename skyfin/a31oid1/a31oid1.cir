* A31OID1 : abstract conversion of sky130_fd_sc_hd__a31oi_1
* 20 abstract devices (width -> parallel min-width fingers)
.subckt A31OID1 A1 A2 A3 B1 VGND VPWR Y
XA31OID1B A1 A2 A3 B1 VGND VGND VPWR VPWR Y A31OID1B
.ends A31OID1

.subckt A31OID1B A1 A2 A3 B1 VGND VNB VPB VPWR Y
X0 a_109_297# B1 Y VPB abpmos
X1 a_109_297# B1 Y VPB abpmos
X2 a_109_297# B1 Y VPB abpmos
X3 a_181_47# A1 Y VNB abnmos
X4 a_181_47# A1 Y VNB abnmos
X5 a_109_297# A1 VPWR VPB abpmos
X6 a_109_297# A1 VPWR VPB abpmos
X7 a_109_297# A1 VPWR VPB abpmos
X8 a_109_47# A2 a_181_47# VNB abnmos
X9 a_109_47# A2 a_181_47# VNB abnmos
X10 Y B1 VGND VNB abnmos
X11 Y B1 VGND VNB abnmos
X12 a_109_47# A3 VGND VNB abnmos
X13 a_109_47# A3 VGND VNB abnmos
X14 a_109_297# A3 VPWR VPB abpmos
X15 a_109_297# A3 VPWR VPB abpmos
X16 a_109_297# A3 VPWR VPB abpmos
X17 a_109_297# A2 VPWR VPB abpmos
X18 a_109_297# A2 VPWR VPB abpmos
X19 a_109_297# A2 VPWR VPB abpmos
.ends A31OID1B
