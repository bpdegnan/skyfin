* SEDFXBPD2 : abstract conversion of sky130_fd_sc_hd__sedfxbp_2
* 74 abstract devices (width -> parallel min-width fingers)
.subckt SEDFXBPD2 CLK D DE SCD SCE VGND VPWR Q Q_N
XSEDFXBPD2B CLK D DE SCD SCE VGND VGND VPWR VPWR Q Q_N SEDFXBPD2B
.ends SEDFXBPD2

.subckt SEDFXBPD2B CLK D DE SCD SCE VGND VNB VPB VPWR Q Q_N
X0 a_1960_413# a_1610_159# VPWR VPB abpmos
X1 Q_N a_791_264# VGND VNB abnmos
X2 Q_N a_791_264# VGND VNB abnmos
X3 a_791_264# a_2051_413# VPWR VPB abpmos
X4 a_791_264# a_2051_413# VPWR VPB abpmos
X5 a_1446_413# a_27_47# a_1537_413# VPB abpmos
X6 a_729_47# a_791_264# a_299_47# VNB abnmos
X7 Q a_2051_413# VGND VNB abnmos
X8 Q a_2051_413# VGND VNB abnmos
X9 a_1231_369# SCD VPWR VPB abpmos
X10 a_1231_369# SCD VPWR VPB abpmos
X11 Q a_2051_413# VPWR VPB abpmos
X12 Q a_2051_413# VPWR VPB abpmos
X13 Q a_2051_413# VPWR VPB abpmos
X14 a_2051_413# a_193_47# a_2135_413# VPB abpmos
X15 Q a_2051_413# VGND VNB abnmos
X16 Q a_2051_413# VGND VNB abnmos
X17 a_299_47# D a_381_369# VPB abpmos
X18 a_299_47# D a_381_369# VPB abpmos
X19 a_381_369# a_423_343# VPWR VPB abpmos
X20 a_381_369# a_423_343# VPWR VPB abpmos
X21 Q a_2051_413# VPWR VPB abpmos
X22 Q a_2051_413# VPWR VPB abpmos
X23 Q a_2051_413# VPWR VPB abpmos
X24 a_1226_119# SCE a_915_47# VNB abnmos
X25 a_1960_413# a_27_47# a_2051_413# VPB abpmos
X26 a_1610_159# a_1446_413# VGND VNB abnmos
X27 a_1610_159# a_1446_413# VGND VNB abnmos
X28 Q_N a_791_264# VGND VNB abnmos
X29 Q_N a_791_264# VGND VNB abnmos
X30 a_1231_369# a_885_21# a_915_47# VPB abpmos
X31 a_1231_369# a_885_21# a_915_47# VPB abpmos
X32 a_2135_413# a_791_264# VPWR VPB abpmos
X33 a_915_47# a_27_47# a_1446_413# VNB abnmos
X34 a_2051_413# a_27_47# a_2177_47# VNB abnmos
X35 a_729_369# DE VPWR VPB abpmos
X36 a_729_369# DE VPWR VPB abpmos
X37 a_299_47# a_885_21# a_915_47# VNB abnmos
X38 a_381_47# DE VGND VNB abnmos
X39 a_1610_159# a_1446_413# VPWR VPB abpmos
X40 a_1610_159# a_1446_413# VPWR VPB abpmos
X41 a_1974_47# a_1610_159# VGND VNB abnmos
X42 a_1974_47# a_193_47# a_2051_413# VNB abnmos
X43 a_1226_119# SCD VGND VNB abnmos
X44 a_729_369# a_791_264# a_299_47# VPB abpmos
X45 a_729_369# a_791_264# a_299_47# VPB abpmos
X46 a_2177_47# a_791_264# VGND VNB abnmos
X47 a_299_47# SCE a_915_47# VPB abpmos
X48 a_299_47# SCE a_915_47# VPB abpmos
X49 a_423_343# DE VGND VNB abnmos
X50 a_915_47# a_193_47# a_1446_413# VPB abpmos
X51 Q_N a_791_264# VPWR VPB abpmos
X52 Q_N a_791_264# VPWR VPB abpmos
X53 Q_N a_791_264# VPWR VPB abpmos
X54 a_791_264# a_2051_413# VGND VNB abnmos
X55 a_885_21# SCE VPWR VPB abpmos
X56 a_885_21# SCE VPWR VPB abpmos
X57 a_193_47# a_27_47# VGND VNB abnmos
X58 a_27_47# CLK VGND VNB abnmos
X59 a_729_47# a_423_343# VGND VNB abnmos
X60 a_1561_47# a_1610_159# VGND VNB abnmos
X61 a_27_47# CLK VPWR VPB abpmos
X62 a_27_47# CLK VPWR VPB abpmos
X63 a_1537_413# a_1610_159# VPWR VPB abpmos
X64 a_193_47# a_27_47# VPWR VPB abpmos
X65 a_193_47# a_27_47# VPWR VPB abpmos
X66 a_299_47# D a_381_47# VNB abnmos
X67 a_1446_413# a_193_47# a_1561_47# VNB abnmos
X68 a_423_343# DE VPWR VPB abpmos
X69 a_423_343# DE VPWR VPB abpmos
X70 a_885_21# SCE VGND VNB abnmos
X71 Q_N a_791_264# VPWR VPB abpmos
X72 Q_N a_791_264# VPWR VPB abpmos
X73 Q_N a_791_264# VPWR VPB abpmos
.ends SEDFXBPD2B
