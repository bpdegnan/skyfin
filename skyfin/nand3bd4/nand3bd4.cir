* NAND3BD4 : abstract conversion of sky130_fd_sc_hd__nand3b_4
* 65 abstract devices (width -> parallel min-width fingers)
.subckt NAND3BD4 A_N B C VGND VPWR Y
XNAND3BD4B A_N B C VGND VGND VPWR VPWR Y NAND3BD4B
.ends NAND3BD4

.subckt NAND3BD4B A_N B C VGND VNB VPB VPWR Y
X0 a_633_47# B a_215_47# VNB abnmos
X1 a_633_47# B a_215_47# VNB abnmos
X2 Y C VPWR VPB abpmos
X3 Y C VPWR VPB abpmos
X4 Y C VPWR VPB abpmos
X5 Y C VPWR VPB abpmos
X6 Y C VPWR VPB abpmos
X7 Y C VPWR VPB abpmos
X8 a_215_47# B a_633_47# VNB abnmos
X9 a_215_47# B a_633_47# VNB abnmos
X10 a_215_47# a_27_47# Y VNB abnmos
X11 a_215_47# a_27_47# Y VNB abnmos
X12 a_215_47# B a_633_47# VNB abnmos
X13 a_215_47# B a_633_47# VNB abnmos
X14 Y a_27_47# VPWR VPB abpmos
X15 Y a_27_47# VPWR VPB abpmos
X16 Y a_27_47# VPWR VPB abpmos
X17 a_633_47# C VGND VNB abnmos
X18 a_633_47# C VGND VNB abnmos
X19 Y a_27_47# VPWR VPB abpmos
X20 Y a_27_47# VPWR VPB abpmos
X21 Y a_27_47# VPWR VPB abpmos
X22 Y a_27_47# VPWR VPB abpmos
X23 Y a_27_47# VPWR VPB abpmos
X24 Y a_27_47# VPWR VPB abpmos
X25 Y B VPWR VPB abpmos
X26 Y B VPWR VPB abpmos
X27 Y B VPWR VPB abpmos
X28 Y a_27_47# VPWR VPB abpmos
X29 Y a_27_47# VPWR VPB abpmos
X30 Y a_27_47# VPWR VPB abpmos
X31 Y C VPWR VPB abpmos
X32 Y C VPWR VPB abpmos
X33 Y C VPWR VPB abpmos
X34 a_633_47# B a_215_47# VNB abnmos
X35 a_633_47# B a_215_47# VNB abnmos
X36 a_633_47# C VGND VNB abnmos
X37 a_633_47# C VGND VNB abnmos
X38 Y a_27_47# a_215_47# VNB abnmos
X39 Y a_27_47# a_215_47# VNB abnmos
X40 a_633_47# C VGND VNB abnmos
X41 a_633_47# C VGND VNB abnmos
X42 a_215_47# a_27_47# Y VNB abnmos
X43 a_215_47# a_27_47# Y VNB abnmos
X44 a_633_47# C VGND VNB abnmos
X45 a_633_47# C VGND VNB abnmos
X46 Y B VPWR VPB abpmos
X47 Y B VPWR VPB abpmos
X48 Y B VPWR VPB abpmos
X49 a_27_47# A_N VGND VNB abnmos
X50 a_27_47# A_N VGND VNB abnmos
X51 Y B VPWR VPB abpmos
X52 Y B VPWR VPB abpmos
X53 Y B VPWR VPB abpmos
X54 a_27_47# A_N VPWR VPB abpmos
X55 a_27_47# A_N VPWR VPB abpmos
X56 a_27_47# A_N VPWR VPB abpmos
X57 Y a_27_47# a_215_47# VNB abnmos
X58 Y a_27_47# a_215_47# VNB abnmos
X59 Y B VPWR VPB abpmos
X60 Y B VPWR VPB abpmos
X61 Y B VPWR VPB abpmos
X62 Y C VPWR VPB abpmos
X63 Y C VPWR VPB abpmos
X64 Y C VPWR VPB abpmos
.ends NAND3BD4B
