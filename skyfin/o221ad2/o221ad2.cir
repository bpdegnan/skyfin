* O221AD2 : abstract conversion of sky130_fd_sc_hd__o221a_2
* 35 abstract devices (width -> parallel min-width fingers)
.subckt O221AD2 A1 A2 B1 B2 C1 VGND VPWR X
XO221AD2B A1 A2 B1 B2 C1 VGND VGND VPWR VPWR X O221AD2B
.ends O221AD2

.subckt O221AD2B A1 A2 B1 B2 C1 VGND VNB VPB VPWR X
X0 X a_38_47# VGND VNB abnmos
X1 X a_38_47# VGND VNB abnmos
X2 a_225_47# A1 VGND VNB abnmos
X3 a_225_47# A1 VGND VNB abnmos
X4 a_38_47# C1 a_141_47# VNB abnmos
X5 a_38_47# C1 a_141_47# VNB abnmos
X6 a_225_47# B2 a_141_47# VNB abnmos
X7 a_225_47# B2 a_141_47# VNB abnmos
X8 a_225_47# A2 VGND VNB abnmos
X9 a_225_47# A2 VGND VNB abnmos
X10 a_141_47# B1 a_225_47# VNB abnmos
X11 a_141_47# B1 a_225_47# VNB abnmos
X12 a_237_297# B2 a_38_47# VPB abpmos
X13 a_237_297# B2 a_38_47# VPB abpmos
X14 a_237_297# B2 a_38_47# VPB abpmos
X15 a_237_297# B1 VPWR VPB abpmos
X16 a_237_297# B1 VPWR VPB abpmos
X17 a_237_297# B1 VPWR VPB abpmos
X18 X a_38_47# VPWR VPB abpmos
X19 X a_38_47# VPWR VPB abpmos
X20 X a_38_47# VPWR VPB abpmos
X21 a_38_47# A2 a_497_297# VPB abpmos
X22 a_38_47# A2 a_497_297# VPB abpmos
X23 a_38_47# A2 a_497_297# VPB abpmos
X24 a_497_297# A1 VPWR VPB abpmos
X25 a_497_297# A1 VPWR VPB abpmos
X26 a_497_297# A1 VPWR VPB abpmos
X27 X a_38_47# VPWR VPB abpmos
X28 X a_38_47# VPWR VPB abpmos
X29 X a_38_47# VPWR VPB abpmos
X30 X a_38_47# VGND VNB abnmos
X31 X a_38_47# VGND VNB abnmos
X32 a_38_47# C1 VPWR VPB abpmos
X33 a_38_47# C1 VPWR VPB abpmos
X34 a_38_47# C1 VPWR VPB abpmos
.ends O221AD2B
