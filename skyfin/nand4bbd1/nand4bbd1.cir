* NAND4BBD1 : abstract conversion of sky130_fd_sc_hd__nand4bb_1
* 24 abstract devices (width -> parallel min-width fingers)
.subckt NAND4BBD1 A_N B_N C D VGND VPWR Y
XNAND4BBD1B A_N B_N C D VGND VGND VPWR VPWR Y NAND4BBD1B
.ends NAND4BBD1

.subckt NAND4BBD1B A_N B_N C D VGND VNB VPB VPWR Y
X0 Y a_496_21# VPWR VPB abpmos
X1 Y a_496_21# VPWR VPB abpmos
X2 Y a_496_21# VPWR VPB abpmos
X3 a_426_47# a_496_21# Y VNB abnmos
X4 a_426_47# a_496_21# Y VNB abnmos
X5 a_496_21# A_N VPWR VPB abpmos
X6 a_496_21# A_N VGND VNB abnmos
X7 a_27_93# B_N VGND VNB abnmos
X8 Y C VPWR VPB abpmos
X9 Y C VPWR VPB abpmos
X10 Y C VPWR VPB abpmos
X11 a_326_47# a_27_93# a_426_47# VNB abnmos
X12 a_326_47# a_27_93# a_426_47# VNB abnmos
X13 a_27_93# B_N VPWR VPB abpmos
X14 Y D VPWR VPB abpmos
X15 Y D VPWR VPB abpmos
X16 Y D VPWR VPB abpmos
X17 Y a_27_93# VPWR VPB abpmos
X18 Y a_27_93# VPWR VPB abpmos
X19 Y a_27_93# VPWR VPB abpmos
X20 a_218_47# D VGND VNB abnmos
X21 a_218_47# D VGND VNB abnmos
X22 a_218_47# C a_326_47# VNB abnmos
X23 a_218_47# C a_326_47# VNB abnmos
.ends NAND4BBD1B
