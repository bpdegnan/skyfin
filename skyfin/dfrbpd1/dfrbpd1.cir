* DFRBPD1 : abstract conversion of sky130_fd_sc_hd__dfrbp_1
* 43 abstract devices (width -> parallel min-width fingers)
.subckt DFRBPD1 CLK D RESET_B VGND VPWR Q Q_N
XDFRBPD1B CLK D RESET_B VGND VGND VPWR VPWR Q Q_N DFRBPD1B
.ends DFRBPD1

.subckt DFRBPD1B CLK D RESET_B VGND VNB VPB VPWR Q Q_N
X0 a_1270_413# a_1283_21# VPWR VPB abpmos
X1 a_761_289# a_543_47# VPWR VPB abpmos
X2 a_761_289# a_543_47# VPWR VPB abpmos
X3 a_761_289# a_543_47# VGND VNB abnmos
X4 a_761_289# a_543_47# VGND VNB abnmos
X5 Q_N a_1847_47# VPWR VPB abpmos
X6 Q_N a_1847_47# VPWR VPB abpmos
X7 Q_N a_1847_47# VPWR VPB abpmos
X8 a_448_47# D VGND VNB abnmos
X9 a_1108_47# a_193_47# a_1270_413# VPB abpmos
X10 a_1217_47# a_1283_21# VGND VNB abnmos
X11 a_448_47# a_27_47# a_543_47# VNB abnmos
X12 a_1847_47# a_1283_21# VGND VNB abnmos
X13 Q a_1283_21# VPWR VPB abpmos
X14 Q a_1283_21# VPWR VPB abpmos
X15 Q a_1283_21# VPWR VPB abpmos
X16 a_448_47# a_193_47# a_543_47# VPB abpmos
X17 a_543_47# a_193_47# a_639_47# VNB abnmos
X18 a_1108_47# a_27_47# a_1217_47# VNB abnmos
X19 a_1462_47# a_1108_47# a_1283_21# VNB abnmos
X20 Q a_1283_21# VGND VNB abnmos
X21 Q a_1283_21# VGND VNB abnmos
X22 a_543_47# a_27_47# a_651_413# VPB abpmos
X23 a_805_47# RESET_B VGND VNB abnmos
X24 a_761_289# a_193_47# a_1108_47# VNB abnmos
X25 a_651_413# RESET_B VPWR VPB abpmos
X26 a_193_47# a_27_47# VGND VNB abnmos
X27 a_27_47# CLK VGND VNB abnmos
X28 a_27_47# CLK VPWR VPB abpmos
X29 a_27_47# CLK VPWR VPB abpmos
X30 a_193_47# a_27_47# VPWR VPB abpmos
X31 a_193_47# a_27_47# VPWR VPB abpmos
X32 a_1283_21# a_1108_47# VPWR VPB abpmos
X33 a_1847_47# a_1283_21# VPWR VPB abpmos
X34 a_1847_47# a_1283_21# VPWR VPB abpmos
X35 a_1462_47# RESET_B VGND VNB abnmos
X36 a_448_47# D VPWR VPB abpmos
X37 a_651_413# a_761_289# VPWR VPB abpmos
X38 a_761_289# a_27_47# a_1108_47# VPB abpmos
X39 Q_N a_1847_47# VGND VNB abnmos
X40 Q_N a_1847_47# VGND VNB abnmos
X41 a_1283_21# RESET_B VPWR VPB abpmos
X42 a_639_47# a_761_289# a_805_47# VNB abnmos
.ends DFRBPD1B
