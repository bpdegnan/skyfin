* LPFLOW_CLKINVKAPWRD1 : abstract conversion of sky130_fd_sc_hd__lpflow_clkinvkapwr_1
* 5 abstract devices (width -> parallel min-width fingers) ; secondary power ['KAPWR'] collapsed onto VPWR
.subckt LPFLOW_CLKINVKAPWRD1 A VGND VPWR Y
XLPFLOW_CLKINVKAPWRD1B A VPWR VGND VGND VPWR VPWR Y LPFLOW_CLKINVKAPWRD1B
.ends LPFLOW_CLKINVKAPWRD1

.subckt LPFLOW_CLKINVKAPWRD1B A KAPWR VGND VNB VPB VPWR Y
X0 Y A KAPWR VPB abpmos
X1 Y A KAPWR VPB abpmos
X2 Y A VGND VNB abnmos
X3 KAPWR A Y VPB abpmos
X4 KAPWR A Y VPB abpmos
.ends LPFLOW_CLKINVKAPWRD1B
