* NAND4D2 : abstract conversion of sky130_fd_sc_hd__nand4_2
* 40 abstract devices (width -> parallel min-width fingers)
.subckt NAND4D2 A B C D VGND VPWR Y
XNAND4D2B A B C D VGND VGND VPWR VPWR Y NAND4D2B
.ends NAND4D2

.subckt NAND4D2B A B C D VGND VNB VPB VPWR Y
X0 Y B VPWR VPB abpmos
X1 Y B VPWR VPB abpmos
X2 Y B VPWR VPB abpmos
X3 a_277_47# C a_27_47# VNB abnmos
X4 a_277_47# C a_27_47# VNB abnmos
X5 Y A VPWR VPB abpmos
X6 Y A VPWR VPB abpmos
X7 Y A VPWR VPB abpmos
X8 Y B VPWR VPB abpmos
X9 Y B VPWR VPB abpmos
X10 Y B VPWR VPB abpmos
X11 Y A VPWR VPB abpmos
X12 Y A VPWR VPB abpmos
X13 Y A VPWR VPB abpmos
X14 a_27_47# C a_277_47# VNB abnmos
X15 a_27_47# C a_277_47# VNB abnmos
X16 a_277_47# B a_471_47# VNB abnmos
X17 a_277_47# B a_471_47# VNB abnmos
X18 a_27_47# D VGND VNB abnmos
X19 a_27_47# D VGND VNB abnmos
X20 Y C VPWR VPB abpmos
X21 Y C VPWR VPB abpmos
X22 Y C VPWR VPB abpmos
X23 a_27_47# D VGND VNB abnmos
X24 a_27_47# D VGND VNB abnmos
X25 Y A a_471_47# VNB abnmos
X26 Y A a_471_47# VNB abnmos
X27 Y D VPWR VPB abpmos
X28 Y D VPWR VPB abpmos
X29 Y D VPWR VPB abpmos
X30 Y D VPWR VPB abpmos
X31 Y D VPWR VPB abpmos
X32 Y D VPWR VPB abpmos
X33 a_471_47# A Y VNB abnmos
X34 a_471_47# A Y VNB abnmos
X35 Y C VPWR VPB abpmos
X36 Y C VPWR VPB abpmos
X37 Y C VPWR VPB abpmos
X38 a_471_47# B a_277_47# VNB abnmos
X39 a_471_47# B a_277_47# VNB abnmos
.ends NAND4D2B
