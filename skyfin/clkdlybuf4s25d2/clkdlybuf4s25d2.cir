* CLKDLYBUF4S25D2 : abstract conversion of sky130_fd_sc_hd__clkdlybuf4s25_2
* 20 abstract devices (width -> parallel min-width fingers)
.subckt CLKDLYBUF4S25D2 A VGND VPWR X
XCLKDLYBUF4S25D2B A VGND VGND VPWR VPWR X CLKDLYBUF4S25D2B
.ends CLKDLYBUF4S25D2

.subckt CLKDLYBUF4S25D2B A VGND VNB VPB VPWR X
X0 X a_331_47# VPWR VPB abpmos
X1 X a_331_47# VPWR VPB abpmos
X2 X a_331_47# VPWR VPB abpmos
X3 a_27_47# A VPWR VPB abpmos
X4 a_27_47# A VPWR VPB abpmos
X5 a_27_47# A VPWR VPB abpmos
X6 a_27_47# A VGND VNB abnmos
X7 X a_331_47# VPWR VPB abpmos
X8 X a_331_47# VPWR VPB abpmos
X9 X a_331_47# VPWR VPB abpmos
X10 X a_331_47# VGND VNB abnmos
X11 a_225_47# a_27_47# VPWR VPB abpmos
X12 a_225_47# a_27_47# VPWR VPB abpmos
X13 a_331_47# a_225_47# VGND VNB abnmos
X14 a_331_47# a_225_47# VGND VNB abnmos
X15 X a_331_47# VGND VNB abnmos
X16 a_331_47# a_225_47# VPWR VPB abpmos
X17 a_331_47# a_225_47# VPWR VPB abpmos
X18 a_225_47# a_27_47# VGND VNB abnmos
X19 a_225_47# a_27_47# VGND VNB abnmos
.ends CLKDLYBUF4S25D2B
