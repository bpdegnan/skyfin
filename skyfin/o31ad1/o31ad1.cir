* O31AD1 : abstract conversion of sky130_fd_sc_hd__o31a_1
* 25 abstract devices (width -> parallel min-width fingers)
.subckt O31AD1 A1 A2 A3 B1 VGND VPWR X
XO31AD1B A1 A2 A3 B1 VGND VGND VPWR VPWR X O31AD1B
.ends O31AD1

.subckt O31AD1B A1 A2 A3 B1 VGND VNB VPB VPWR X
X0 a_253_47# A2 VGND VNB abnmos
X1 a_253_47# A2 VGND VNB abnmos
X2 a_253_297# A1 VPWR VPB abpmos
X3 a_253_297# A1 VPWR VPB abpmos
X4 a_253_297# A1 VPWR VPB abpmos
X5 X a_103_199# VGND VNB abnmos
X6 X a_103_199# VGND VNB abnmos
X7 X a_103_199# VPWR VPB abpmos
X8 X a_103_199# VPWR VPB abpmos
X9 X a_103_199# VPWR VPB abpmos
X10 a_253_47# A1 VGND VNB abnmos
X11 a_253_47# A1 VGND VNB abnmos
X12 a_103_199# B1 VPWR VPB abpmos
X13 a_103_199# B1 VPWR VPB abpmos
X14 a_103_199# B1 VPWR VPB abpmos
X15 a_253_47# B1 a_103_199# VNB abnmos
X16 a_253_47# B1 a_103_199# VNB abnmos
X17 a_253_47# A3 VGND VNB abnmos
X18 a_253_47# A3 VGND VNB abnmos
X19 a_253_297# A2 a_337_297# VPB abpmos
X20 a_253_297# A2 a_337_297# VPB abpmos
X21 a_253_297# A2 a_337_297# VPB abpmos
X22 a_337_297# A3 a_103_199# VPB abpmos
X23 a_337_297# A3 a_103_199# VPB abpmos
X24 a_337_297# A3 a_103_199# VPB abpmos
.ends O31AD1B
