* O221AID1 : abstract conversion of sky130_fd_sc_hd__o221ai_1
* 25 abstract devices (width -> parallel min-width fingers)
.subckt O221AID1 A1 A2 B1 B2 C1 VGND VPWR Y
XO221AID1B A1 A2 B1 B2 C1 VGND VGND VPWR VPWR Y O221AID1B
.ends O221AID1

.subckt O221AID1B A1 A2 B1 B2 C1 VGND VNB VPB VPWR Y
X0 a_295_297# B1 VPWR VPB abpmos
X1 a_295_297# B1 VPWR VPB abpmos
X2 a_295_297# B1 VPWR VPB abpmos
X3 Y C1 VPWR VPB abpmos
X4 Y C1 VPWR VPB abpmos
X5 Y C1 VPWR VPB abpmos
X6 a_213_123# A1 VGND VNB abnmos
X7 a_213_123# A1 VGND VNB abnmos
X8 a_213_123# A2 VGND VNB abnmos
X9 a_213_123# A2 VGND VNB abnmos
X10 Y A2 a_493_297# VPB abpmos
X11 Y A2 a_493_297# VPB abpmos
X12 Y A2 a_493_297# VPB abpmos
X13 a_493_297# A1 VPWR VPB abpmos
X14 a_493_297# A1 VPWR VPB abpmos
X15 a_493_297# A1 VPWR VPB abpmos
X16 a_109_47# B2 a_213_123# VNB abnmos
X17 a_109_47# B2 a_213_123# VNB abnmos
X18 Y C1 a_109_47# VNB abnmos
X19 Y C1 a_109_47# VNB abnmos
X20 a_295_297# B2 Y VPB abpmos
X21 a_295_297# B2 Y VPB abpmos
X22 a_295_297# B2 Y VPB abpmos
X23 a_213_123# B1 a_109_47# VNB abnmos
X24 a_213_123# B1 a_109_47# VNB abnmos
.ends O221AID1B
