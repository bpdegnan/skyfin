* A41OD1 : abstract conversion of sky130_fd_sc_hd__a41o_1
* 30 abstract devices (width -> parallel min-width fingers)
.subckt A41OD1 A1 A2 A3 A4 B1 VGND VPWR X
XA41OD1B A1 A2 A3 A4 B1 VGND VGND VPWR VPWR X A41OD1B
.ends A41OD1

.subckt A41OD1B A1 A2 A3 A4 B1 VGND VNB VPB VPWR X
X0 a_79_21# B1 VGND VNB abnmos
X1 a_79_21# B1 VGND VNB abnmos
X2 a_297_297# A4 VPWR VPB abpmos
X3 a_297_297# A4 VPWR VPB abpmos
X4 a_297_297# A4 VPWR VPB abpmos
X5 a_79_21# B1 a_297_297# VPB abpmos
X6 a_79_21# B1 a_297_297# VPB abpmos
X7 a_79_21# B1 a_297_297# VPB abpmos
X8 a_297_297# A2 VPWR VPB abpmos
X9 a_297_297# A2 VPWR VPB abpmos
X10 a_297_297# A2 VPWR VPB abpmos
X11 a_297_297# A3 VPWR VPB abpmos
X12 a_297_297# A3 VPWR VPB abpmos
X13 a_297_297# A3 VPWR VPB abpmos
X14 a_297_297# A1 VPWR VPB abpmos
X15 a_297_297# A1 VPWR VPB abpmos
X16 a_297_297# A1 VPWR VPB abpmos
X17 a_465_47# A3 a_561_47# VNB abnmos
X18 a_465_47# A3 a_561_47# VNB abnmos
X19 a_561_47# A4 VGND VNB abnmos
X20 a_561_47# A4 VGND VNB abnmos
X21 a_381_47# A2 a_465_47# VNB abnmos
X22 a_381_47# A2 a_465_47# VNB abnmos
X23 X a_79_21# VGND VNB abnmos
X24 X a_79_21# VGND VNB abnmos
X25 X a_79_21# VPWR VPB abpmos
X26 X a_79_21# VPWR VPB abpmos
X27 X a_79_21# VPWR VPB abpmos
X28 a_79_21# A1 a_381_47# VNB abnmos
X29 a_79_21# A1 a_381_47# VNB abnmos
.ends A41OD1B
