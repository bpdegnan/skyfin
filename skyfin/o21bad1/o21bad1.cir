* O21BAD1 : abstract conversion of sky130_fd_sc_hd__o21ba_1
* 22 abstract devices (width -> parallel min-width fingers)
.subckt O21BAD1 A1 A2 B1_N VGND VPWR X
XO21BAD1B A1 A2 B1_N VGND VGND VPWR VPWR X O21BAD1B
.ends O21BAD1

.subckt O21BAD1B A1 A2 B1_N VGND VNB VPB VPWR X
X0 a_448_47# A2 VGND VNB abnmos
X1 a_448_47# A2 VGND VNB abnmos
X2 a_222_93# B1_N VPWR VPB abpmos
X3 a_79_199# a_222_93# a_448_47# VNB abnmos
X4 a_79_199# a_222_93# a_448_47# VNB abnmos
X5 a_222_93# B1_N VGND VNB abnmos
X6 a_448_47# A1 VGND VNB abnmos
X7 a_448_47# A1 VGND VNB abnmos
X8 a_544_297# A1 VPWR VPB abpmos
X9 a_544_297# A1 VPWR VPB abpmos
X10 a_544_297# A1 VPWR VPB abpmos
X11 X a_79_199# VGND VNB abnmos
X12 X a_79_199# VGND VNB abnmos
X13 X a_79_199# VPWR VPB abpmos
X14 X a_79_199# VPWR VPB abpmos
X15 X a_79_199# VPWR VPB abpmos
X16 a_79_199# a_222_93# VPWR VPB abpmos
X17 a_79_199# a_222_93# VPWR VPB abpmos
X18 a_79_199# a_222_93# VPWR VPB abpmos
X19 a_79_199# A2 a_544_297# VPB abpmos
X20 a_79_199# A2 a_544_297# VPB abpmos
X21 a_79_199# A2 a_544_297# VPB abpmos
.ends O21BAD1B
