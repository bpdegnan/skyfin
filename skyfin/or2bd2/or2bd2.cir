* OR2BD2 : abstract conversion of sky130_fd_sc_hd__or2b_2
* 16 abstract devices (width -> parallel min-width fingers)
.subckt OR2BD2 A B_N VGND VPWR X
XOR2BD2B A B_N VGND VGND VPWR VPWR X OR2BD2B
.ends OR2BD2

.subckt OR2BD2B A B_N VGND VNB VPB VPWR X
X0 X a_218_297# VGND VNB abnmos
X1 X a_218_297# VGND VNB abnmos
X2 a_218_297# A VGND VNB abnmos
X3 a_27_53# B_N VGND VNB abnmos
X4 a_218_297# a_27_53# a_300_297# VPB abpmos
X5 a_300_297# A VPWR VPB abpmos
X6 X a_218_297# VPWR VPB abpmos
X7 X a_218_297# VPWR VPB abpmos
X8 X a_218_297# VPWR VPB abpmos
X9 a_27_53# B_N VPWR VPB abpmos
X10 X a_218_297# VGND VNB abnmos
X11 X a_218_297# VGND VNB abnmos
X12 X a_218_297# VPWR VPB abpmos
X13 X a_218_297# VPWR VPB abpmos
X14 X a_218_297# VPWR VPB abpmos
X15 a_218_297# a_27_53# VGND VNB abnmos
.ends OR2BD2B
