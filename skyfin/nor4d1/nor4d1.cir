* NOR4D1 : abstract conversion of sky130_fd_sc_hd__nor4_1
* 20 abstract devices (width -> parallel min-width fingers)
.subckt NOR4D1 A B C D VGND VPWR Y
XNOR4D1B A B C D VGND VGND VPWR VPWR Y NOR4D1B
.ends NOR4D1

.subckt NOR4D1B A B C D VGND VNB VPB VPWR Y
X0 Y B VGND VNB abnmos
X1 Y B VGND VNB abnmos
X2 a_191_297# B a_297_297# VPB abpmos
X3 a_191_297# B a_297_297# VPB abpmos
X4 a_191_297# B a_297_297# VPB abpmos
X5 a_297_297# A VPWR VPB abpmos
X6 a_297_297# A VPWR VPB abpmos
X7 a_297_297# A VPWR VPB abpmos
X8 Y C VGND VNB abnmos
X9 Y C VGND VNB abnmos
X10 Y D VGND VNB abnmos
X11 Y D VGND VNB abnmos
X12 a_109_297# C a_191_297# VPB abpmos
X13 a_109_297# C a_191_297# VPB abpmos
X14 a_109_297# C a_191_297# VPB abpmos
X15 Y D a_109_297# VPB abpmos
X16 Y D a_109_297# VPB abpmos
X17 Y D a_109_297# VPB abpmos
X18 Y A VGND VNB abnmos
X19 Y A VGND VNB abnmos
.ends NOR4D1B
