* NOR4BD4 : abstract conversion of sky130_fd_sc_hd__nor4b_4
* 85 abstract devices (width -> parallel min-width fingers)
.subckt NOR4BD4 A B C D_N VGND VPWR Y
XNOR4BD4B A B C D_N VGND VGND VPWR VPWR Y NOR4BD4B
.ends NOR4BD4

.subckt NOR4BD4B A B C D_N VGND VNB VPB VPWR Y
X0 Y a_1191_21# a_803_297# VPB abpmos
X1 Y a_1191_21# a_803_297# VPB abpmos
X2 Y a_1191_21# a_803_297# VPB abpmos
X3 Y C VGND VNB abnmos
X4 Y C VGND VNB abnmos
X5 Y B VGND VNB abnmos
X6 Y B VGND VNB abnmos
X7 Y a_1191_21# VGND VNB abnmos
X8 Y a_1191_21# VGND VNB abnmos
X9 Y B VGND VNB abnmos
X10 Y B VGND VNB abnmos
X11 a_803_297# a_1191_21# Y VPB abpmos
X12 a_803_297# a_1191_21# Y VPB abpmos
X13 a_803_297# a_1191_21# Y VPB abpmos
X14 Y C VGND VNB abnmos
X15 Y C VGND VNB abnmos
X16 a_445_297# B a_27_297# VPB abpmos
X17 a_445_297# B a_27_297# VPB abpmos
X18 a_445_297# B a_27_297# VPB abpmos
X19 a_445_297# B a_27_297# VPB abpmos
X20 a_445_297# B a_27_297# VPB abpmos
X21 a_445_297# B a_27_297# VPB abpmos
X22 Y A VGND VNB abnmos
X23 Y A VGND VNB abnmos
X24 a_27_297# B a_445_297# VPB abpmos
X25 a_27_297# B a_445_297# VPB abpmos
X26 a_27_297# B a_445_297# VPB abpmos
X27 Y B VGND VNB abnmos
X28 Y B VGND VNB abnmos
X29 Y a_1191_21# VGND VNB abnmos
X30 Y a_1191_21# VGND VNB abnmos
X31 a_445_297# C a_803_297# VPB abpmos
X32 a_445_297# C a_803_297# VPB abpmos
X33 a_445_297# C a_803_297# VPB abpmos
X34 a_803_297# C a_445_297# VPB abpmos
X35 a_803_297# C a_445_297# VPB abpmos
X36 a_803_297# C a_445_297# VPB abpmos
X37 a_1191_21# D_N VGND VNB abnmos
X38 a_1191_21# D_N VGND VNB abnmos
X39 Y A VGND VNB abnmos
X40 Y A VGND VNB abnmos
X41 a_1191_21# D_N VPWR VPB abpmos
X42 a_1191_21# D_N VPWR VPB abpmos
X43 a_1191_21# D_N VPWR VPB abpmos
X44 a_445_297# C a_803_297# VPB abpmos
X45 a_445_297# C a_803_297# VPB abpmos
X46 a_445_297# C a_803_297# VPB abpmos
X47 Y A VGND VNB abnmos
X48 Y A VGND VNB abnmos
X49 a_27_297# A VPWR VPB abpmos
X50 a_27_297# A VPWR VPB abpmos
X51 a_27_297# A VPWR VPB abpmos
X52 Y A VGND VNB abnmos
X53 Y A VGND VNB abnmos
X54 a_803_297# C a_445_297# VPB abpmos
X55 a_803_297# C a_445_297# VPB abpmos
X56 a_803_297# C a_445_297# VPB abpmos
X57 Y a_1191_21# VGND VNB abnmos
X58 Y a_1191_21# VGND VNB abnmos
X59 a_27_297# B a_445_297# VPB abpmos
X60 a_27_297# B a_445_297# VPB abpmos
X61 a_27_297# B a_445_297# VPB abpmos
X62 a_27_297# A VPWR VPB abpmos
X63 a_27_297# A VPWR VPB abpmos
X64 a_27_297# A VPWR VPB abpmos
X65 a_803_297# a_1191_21# Y VPB abpmos
X66 a_803_297# a_1191_21# Y VPB abpmos
X67 a_803_297# a_1191_21# Y VPB abpmos
X68 a_27_297# A VPWR VPB abpmos
X69 a_27_297# A VPWR VPB abpmos
X70 a_27_297# A VPWR VPB abpmos
X71 Y C VGND VNB abnmos
X72 Y C VGND VNB abnmos
X73 Y B VGND VNB abnmos
X74 Y B VGND VNB abnmos
X75 Y a_1191_21# VGND VNB abnmos
X76 Y a_1191_21# VGND VNB abnmos
X77 a_27_297# A VPWR VPB abpmos
X78 a_27_297# A VPWR VPB abpmos
X79 a_27_297# A VPWR VPB abpmos
X80 Y a_1191_21# a_803_297# VPB abpmos
X81 Y a_1191_21# a_803_297# VPB abpmos
X82 Y a_1191_21# a_803_297# VPB abpmos
X83 Y C VGND VNB abnmos
X84 Y C VGND VNB abnmos
.ends NOR4BD4B
