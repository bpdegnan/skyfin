* A2BB2OID1 : abstract conversion of sky130_fd_sc_hd__a2bb2oi_1
* 25 abstract devices (width -> parallel min-width fingers)
.subckt A2BB2OID1 A1_N A2_N B1 B2 VGND VPWR Y
XA2BB2OID1B A1_N A2_N B1 B2 VGND VGND VPWR VPWR Y A2BB2OID1B
.ends A2BB2OID1

.subckt A2BB2OID1B A1_N A2_N B1 B2 VGND VNB VPB VPWR Y
X0 a_109_297# A2_N a_109_47# VPB abpmos
X1 a_109_297# A2_N a_109_47# VPB abpmos
X2 a_109_297# A2_N a_109_47# VPB abpmos
X3 a_481_47# B1 VGND VNB abnmos
X4 a_481_47# B1 VGND VNB abnmos
X5 Y B2 a_481_47# VNB abnmos
X6 Y B2 a_481_47# VNB abnmos
X7 Y a_109_47# a_397_297# VPB abpmos
X8 Y a_109_47# a_397_297# VPB abpmos
X9 Y a_109_47# a_397_297# VPB abpmos
X10 a_397_297# B1 VPWR VPB abpmos
X11 a_397_297# B1 VPWR VPB abpmos
X12 a_397_297# B1 VPWR VPB abpmos
X13 a_397_297# B2 VPWR VPB abpmos
X14 a_397_297# B2 VPWR VPB abpmos
X15 a_397_297# B2 VPWR VPB abpmos
X16 a_109_47# A2_N VGND VNB abnmos
X17 a_109_47# A2_N VGND VNB abnmos
X18 a_109_47# A1_N VGND VNB abnmos
X19 a_109_47# A1_N VGND VNB abnmos
X20 a_109_297# A1_N VPWR VPB abpmos
X21 a_109_297# A1_N VPWR VPB abpmos
X22 a_109_297# A1_N VPWR VPB abpmos
X23 Y a_109_47# VGND VNB abnmos
X24 Y a_109_47# VGND VNB abnmos
.ends A2BB2OID1B
