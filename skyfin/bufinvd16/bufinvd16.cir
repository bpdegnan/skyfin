* BUFINVD16 : abstract conversion of sky130_fd_sc_hd__bufinv_16
* 125 abstract devices (width -> parallel min-width fingers)
.subckt BUFINVD16 A VGND VPWR Y
XBUFINVD16B A VGND VGND VPWR VPWR Y BUFINVD16B
.ends BUFINVD16

.subckt BUFINVD16B A VGND VNB VPB VPWR Y
X0 Y a_361_47# VPWR VPB abpmos
X1 Y a_361_47# VPWR VPB abpmos
X2 Y a_361_47# VPWR VPB abpmos
X3 Y a_361_47# VPWR VPB abpmos
X4 Y a_361_47# VPWR VPB abpmos
X5 Y a_361_47# VPWR VPB abpmos
X6 a_361_47# a_27_47# VGND VNB abnmos
X7 a_361_47# a_27_47# VGND VNB abnmos
X8 a_361_47# a_27_47# VGND VNB abnmos
X9 a_361_47# a_27_47# VGND VNB abnmos
X10 Y a_361_47# VGND VNB abnmos
X11 Y a_361_47# VGND VNB abnmos
X12 Y a_361_47# VGND VNB abnmos
X13 Y a_361_47# VGND VNB abnmos
X14 Y a_361_47# VPWR VPB abpmos
X15 Y a_361_47# VPWR VPB abpmos
X16 Y a_361_47# VPWR VPB abpmos
X17 a_361_47# a_27_47# VPWR VPB abpmos
X18 a_361_47# a_27_47# VPWR VPB abpmos
X19 a_361_47# a_27_47# VPWR VPB abpmos
X20 Y a_361_47# VPWR VPB abpmos
X21 Y a_361_47# VPWR VPB abpmos
X22 Y a_361_47# VPWR VPB abpmos
X23 Y a_361_47# VGND VNB abnmos
X24 Y a_361_47# VGND VNB abnmos
X25 a_361_47# a_27_47# VPWR VPB abpmos
X26 a_361_47# a_27_47# VPWR VPB abpmos
X27 a_361_47# a_27_47# VPWR VPB abpmos
X28 a_361_47# a_27_47# VGND VNB abnmos
X29 a_361_47# a_27_47# VGND VNB abnmos
X30 Y a_361_47# VPWR VPB abpmos
X31 Y a_361_47# VPWR VPB abpmos
X32 Y a_361_47# VPWR VPB abpmos
X33 Y a_361_47# VGND VNB abnmos
X34 Y a_361_47# VGND VNB abnmos
X35 Y a_361_47# VPWR VPB abpmos
X36 Y a_361_47# VPWR VPB abpmos
X37 Y a_361_47# VPWR VPB abpmos
X38 Y a_361_47# VGND VNB abnmos
X39 Y a_361_47# VGND VNB abnmos
X40 a_361_47# a_27_47# VPWR VPB abpmos
X41 a_361_47# a_27_47# VPWR VPB abpmos
X42 a_361_47# a_27_47# VPWR VPB abpmos
X43 Y a_361_47# VPWR VPB abpmos
X44 Y a_361_47# VPWR VPB abpmos
X45 Y a_361_47# VPWR VPB abpmos
X46 a_361_47# a_27_47# VPWR VPB abpmos
X47 a_361_47# a_27_47# VPWR VPB abpmos
X48 a_361_47# a_27_47# VPWR VPB abpmos
X49 Y a_361_47# VPWR VPB abpmos
X50 Y a_361_47# VPWR VPB abpmos
X51 Y a_361_47# VPWR VPB abpmos
X52 a_361_47# a_27_47# VGND VNB abnmos
X53 a_361_47# a_27_47# VGND VNB abnmos
X54 Y a_361_47# VPWR VPB abpmos
X55 Y a_361_47# VPWR VPB abpmos
X56 Y a_361_47# VPWR VPB abpmos
X57 Y a_361_47# VGND VNB abnmos
X58 Y a_361_47# VGND VNB abnmos
X59 Y a_361_47# VGND VNB abnmos
X60 Y a_361_47# VGND VNB abnmos
X61 Y a_361_47# VGND VNB abnmos
X62 Y a_361_47# VGND VNB abnmos
X63 Y a_361_47# VPWR VPB abpmos
X64 Y a_361_47# VPWR VPB abpmos
X65 Y a_361_47# VPWR VPB abpmos
X66 Y a_361_47# VGND VNB abnmos
X67 Y a_361_47# VGND VNB abnmos
X68 Y a_361_47# VGND VNB abnmos
X69 Y a_361_47# VGND VNB abnmos
X70 Y a_361_47# VPWR VPB abpmos
X71 Y a_361_47# VPWR VPB abpmos
X72 Y a_361_47# VPWR VPB abpmos
X73 a_361_47# a_27_47# VGND VNB abnmos
X74 a_361_47# a_27_47# VGND VNB abnmos
X75 a_27_47# A VGND VNB abnmos
X76 a_27_47# A VGND VNB abnmos
X77 Y a_361_47# VGND VNB abnmos
X78 Y a_361_47# VGND VNB abnmos
X79 Y a_361_47# VGND VNB abnmos
X80 Y a_361_47# VGND VNB abnmos
X81 a_27_47# A VGND VNB abnmos
X82 a_27_47# A VGND VNB abnmos
X83 Y a_361_47# VGND VNB abnmos
X84 Y a_361_47# VGND VNB abnmos
X85 a_27_47# A VPWR VPB abpmos
X86 a_27_47# A VPWR VPB abpmos
X87 a_27_47# A VPWR VPB abpmos
X88 Y a_361_47# VPWR VPB abpmos
X89 Y a_361_47# VPWR VPB abpmos
X90 Y a_361_47# VPWR VPB abpmos
X91 a_27_47# A VGND VNB abnmos
X92 a_27_47# A VGND VNB abnmos
X93 Y a_361_47# VPWR VPB abpmos
X94 Y a_361_47# VPWR VPB abpmos
X95 Y a_361_47# VPWR VPB abpmos
X96 Y a_361_47# VPWR VPB abpmos
X97 Y a_361_47# VPWR VPB abpmos
X98 Y a_361_47# VPWR VPB abpmos
X99 Y a_361_47# VGND VNB abnmos
X100 Y a_361_47# VGND VNB abnmos
X101 Y a_361_47# VGND VNB abnmos
X102 Y a_361_47# VGND VNB abnmos
X103 a_361_47# a_27_47# VPWR VPB abpmos
X104 a_361_47# a_27_47# VPWR VPB abpmos
X105 a_361_47# a_27_47# VPWR VPB abpmos
X106 a_27_47# A VPWR VPB abpmos
X107 a_27_47# A VPWR VPB abpmos
X108 a_27_47# A VPWR VPB abpmos
X109 a_27_47# A VPWR VPB abpmos
X110 a_27_47# A VPWR VPB abpmos
X111 a_27_47# A VPWR VPB abpmos
X112 Y a_361_47# VPWR VPB abpmos
X113 Y a_361_47# VPWR VPB abpmos
X114 Y a_361_47# VPWR VPB abpmos
X115 Y a_361_47# VPWR VPB abpmos
X116 Y a_361_47# VPWR VPB abpmos
X117 Y a_361_47# VPWR VPB abpmos
X118 a_361_47# a_27_47# VGND VNB abnmos
X119 a_361_47# a_27_47# VGND VNB abnmos
X120 a_361_47# a_27_47# VPWR VPB abpmos
X121 a_361_47# a_27_47# VPWR VPB abpmos
X122 a_361_47# a_27_47# VPWR VPB abpmos
X123 Y a_361_47# VGND VNB abnmos
X124 Y a_361_47# VGND VNB abnmos
.ends BUFINVD16B
