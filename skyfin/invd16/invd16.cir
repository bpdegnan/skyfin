* INVD16 : abstract conversion of sky130_fd_sc_hd__inv_16
* 80 abstract devices (width -> parallel min-width fingers)
.subckt INVD16 A VGND VPWR Y
XINVD16B A VGND VGND VPWR VPWR Y INVD16B
.ends INVD16

.subckt INVD16B A VGND VNB VPB VPWR Y
X0 Y A VGND VNB abnmos
X1 Y A VGND VNB abnmos
X2 Y A VGND VNB abnmos
X3 Y A VGND VNB abnmos
X4 Y A VPWR VPB abpmos
X5 Y A VPWR VPB abpmos
X6 Y A VPWR VPB abpmos
X7 Y A VPWR VPB abpmos
X8 Y A VPWR VPB abpmos
X9 Y A VPWR VPB abpmos
X10 Y A VGND VNB abnmos
X11 Y A VGND VNB abnmos
X12 Y A VPWR VPB abpmos
X13 Y A VPWR VPB abpmos
X14 Y A VPWR VPB abpmos
X15 Y A VGND VNB abnmos
X16 Y A VGND VNB abnmos
X17 Y A VPWR VPB abpmos
X18 Y A VPWR VPB abpmos
X19 Y A VPWR VPB abpmos
X20 Y A VGND VNB abnmos
X21 Y A VGND VNB abnmos
X22 Y A VPWR VPB abpmos
X23 Y A VPWR VPB abpmos
X24 Y A VPWR VPB abpmos
X25 Y A VGND VNB abnmos
X26 Y A VGND VNB abnmos
X27 Y A VPWR VPB abpmos
X28 Y A VPWR VPB abpmos
X29 Y A VPWR VPB abpmos
X30 Y A VPWR VPB abpmos
X31 Y A VPWR VPB abpmos
X32 Y A VPWR VPB abpmos
X33 Y A VGND VNB abnmos
X34 Y A VGND VNB abnmos
X35 Y A VPWR VPB abpmos
X36 Y A VPWR VPB abpmos
X37 Y A VPWR VPB abpmos
X38 Y A VGND VNB abnmos
X39 Y A VGND VNB abnmos
X40 Y A VPWR VPB abpmos
X41 Y A VPWR VPB abpmos
X42 Y A VPWR VPB abpmos
X43 Y A VGND VNB abnmos
X44 Y A VGND VNB abnmos
X45 Y A VGND VNB abnmos
X46 Y A VGND VNB abnmos
X47 Y A VPWR VPB abpmos
X48 Y A VPWR VPB abpmos
X49 Y A VPWR VPB abpmos
X50 Y A VGND VNB abnmos
X51 Y A VGND VNB abnmos
X52 Y A VGND VNB abnmos
X53 Y A VGND VNB abnmos
X54 Y A VGND VNB abnmos
X55 Y A VGND VNB abnmos
X56 Y A VPWR VPB abpmos
X57 Y A VPWR VPB abpmos
X58 Y A VPWR VPB abpmos
X59 Y A VPWR VPB abpmos
X60 Y A VPWR VPB abpmos
X61 Y A VPWR VPB abpmos
X62 Y A VPWR VPB abpmos
X63 Y A VPWR VPB abpmos
X64 Y A VPWR VPB abpmos
X65 Y A VGND VNB abnmos
X66 Y A VGND VNB abnmos
X67 Y A VPWR VPB abpmos
X68 Y A VPWR VPB abpmos
X69 Y A VPWR VPB abpmos
X70 Y A VPWR VPB abpmos
X71 Y A VPWR VPB abpmos
X72 Y A VPWR VPB abpmos
X73 Y A VGND VNB abnmos
X74 Y A VGND VNB abnmos
X75 Y A VGND VNB abnmos
X76 Y A VGND VNB abnmos
X77 Y A VPWR VPB abpmos
X78 Y A VPWR VPB abpmos
X79 Y A VPWR VPB abpmos
.ends INVD16B
