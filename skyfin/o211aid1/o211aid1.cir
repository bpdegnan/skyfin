* O211AID1 : abstract conversion of sky130_fd_sc_hd__o211ai_1
* 20 abstract devices (width -> parallel min-width fingers)
.subckt O211AID1 A1 A2 B1 C1 VGND VPWR Y
XO211AID1B A1 A2 B1 C1 VGND VGND VPWR VPWR Y O211AID1B
.ends O211AID1

.subckt O211AID1B A1 A2 B1 C1 VGND VNB VPB VPWR Y
X0 a_110_297# A2 Y VPB abpmos
X1 a_110_297# A2 Y VPB abpmos
X2 a_110_297# A2 Y VPB abpmos
X3 a_110_297# A1 VPWR VPB abpmos
X4 a_110_297# A1 VPWR VPB abpmos
X5 a_110_297# A1 VPWR VPB abpmos
X6 a_27_47# A1 VGND VNB abnmos
X7 a_27_47# A1 VGND VNB abnmos
X8 a_326_47# C1 Y VNB abnmos
X9 a_326_47# C1 Y VNB abnmos
X10 Y C1 VPWR VPB abpmos
X11 Y C1 VPWR VPB abpmos
X12 Y C1 VPWR VPB abpmos
X13 a_27_47# A2 VGND VNB abnmos
X14 a_27_47# A2 VGND VNB abnmos
X15 a_27_47# B1 a_326_47# VNB abnmos
X16 a_27_47# B1 a_326_47# VNB abnmos
X17 Y B1 VPWR VPB abpmos
X18 Y B1 VPWR VPB abpmos
X19 Y B1 VPWR VPB abpmos
.ends O211AID1B
