* A31OD2 : abstract conversion of sky130_fd_sc_hd__a31o_2
* 30 abstract devices (width -> parallel min-width fingers)
.subckt A31OD2 A1 A2 A3 B1 VGND VPWR X
XA31OD2B A1 A2 A3 B1 VGND VGND VPWR VPWR X A31OD2B
.ends A31OD2

.subckt A31OD2B A1 A2 A3 B1 VGND VNB VPB VPWR X
X0 a_277_47# A2 a_361_47# VNB abnmos
X1 a_277_47# A2 a_361_47# VNB abnmos
X2 a_361_47# A1 a_79_21# VNB abnmos
X3 a_361_47# A1 a_79_21# VNB abnmos
X4 a_79_21# B1 VGND VNB abnmos
X5 a_79_21# B1 VGND VNB abnmos
X6 a_277_47# A3 VGND VNB abnmos
X7 a_277_47# A3 VGND VNB abnmos
X8 a_277_297# A1 VPWR VPB abpmos
X9 a_277_297# A1 VPWR VPB abpmos
X10 a_277_297# A1 VPWR VPB abpmos
X11 a_277_297# B1 a_79_21# VPB abpmos
X12 a_277_297# B1 a_79_21# VPB abpmos
X13 a_277_297# B1 a_79_21# VPB abpmos
X14 X a_79_21# VGND VNB abnmos
X15 X a_79_21# VGND VNB abnmos
X16 a_277_297# A3 VPWR VPB abpmos
X17 a_277_297# A3 VPWR VPB abpmos
X18 a_277_297# A3 VPWR VPB abpmos
X19 X a_79_21# VGND VNB abnmos
X20 X a_79_21# VGND VNB abnmos
X21 X a_79_21# VPWR VPB abpmos
X22 X a_79_21# VPWR VPB abpmos
X23 X a_79_21# VPWR VPB abpmos
X24 X a_79_21# VPWR VPB abpmos
X25 X a_79_21# VPWR VPB abpmos
X26 X a_79_21# VPWR VPB abpmos
X27 a_277_297# A2 VPWR VPB abpmos
X28 a_277_297# A2 VPWR VPB abpmos
X29 a_277_297# A2 VPWR VPB abpmos
.ends A31OD2B
