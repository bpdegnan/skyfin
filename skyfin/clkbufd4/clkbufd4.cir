* CLKBUFD4 : abstract conversion of sky130_fd_sc_hd__clkbuf_4
* 20 abstract devices (width -> parallel min-width fingers)
.subckt CLKBUFD4 A VGND VPWR X
XCLKBUFD4B A VGND VGND VPWR VPWR X CLKBUFD4B
.ends CLKBUFD4

.subckt CLKBUFD4B A VGND VNB VPB VPWR X
X0 X a_27_47# VPWR VPB abpmos
X1 X a_27_47# VPWR VPB abpmos
X2 X a_27_47# VPWR VPB abpmos
X3 X a_27_47# VPWR VPB abpmos
X4 X a_27_47# VPWR VPB abpmos
X5 X a_27_47# VPWR VPB abpmos
X6 a_27_47# A VPWR VPB abpmos
X7 a_27_47# A VPWR VPB abpmos
X8 a_27_47# A VPWR VPB abpmos
X9 a_27_47# A VGND VNB abnmos
X10 X a_27_47# VPWR VPB abpmos
X11 X a_27_47# VPWR VPB abpmos
X12 X a_27_47# VPWR VPB abpmos
X13 X a_27_47# VGND VNB abnmos
X14 X a_27_47# VGND VNB abnmos
X15 X a_27_47# VGND VNB abnmos
X16 X a_27_47# VGND VNB abnmos
X17 X a_27_47# VPWR VPB abpmos
X18 X a_27_47# VPWR VPB abpmos
X19 X a_27_47# VPWR VPB abpmos
.ends CLKBUFD4B
