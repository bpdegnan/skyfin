* BUFD12 : abstract conversion of sky130_fd_sc_hd__buf_12
* 80 abstract devices (width -> parallel min-width fingers)
.subckt BUFD12 A VGND VPWR X
XBUFD12B A VGND VGND VPWR VPWR X BUFD12B
.ends BUFD12

.subckt BUFD12B A VGND VNB VPB VPWR X
X0 X a_109_47# VPWR VPB abpmos
X1 X a_109_47# VPWR VPB abpmos
X2 X a_109_47# VPWR VPB abpmos
X3 X a_109_47# VGND VNB abnmos
X4 X a_109_47# VGND VNB abnmos
X5 X a_109_47# VGND VNB abnmos
X6 X a_109_47# VGND VNB abnmos
X7 X a_109_47# VPWR VPB abpmos
X8 X a_109_47# VPWR VPB abpmos
X9 X a_109_47# VPWR VPB abpmos
X10 X a_109_47# VPWR VPB abpmos
X11 X a_109_47# VPWR VPB abpmos
X12 X a_109_47# VPWR VPB abpmos
X13 X a_109_47# VGND VNB abnmos
X14 X a_109_47# VGND VNB abnmos
X15 X a_109_47# VPWR VPB abpmos
X16 X a_109_47# VPWR VPB abpmos
X17 X a_109_47# VPWR VPB abpmos
X18 a_109_47# A VGND VNB abnmos
X19 a_109_47# A VGND VNB abnmos
X20 X a_109_47# VPWR VPB abpmos
X21 X a_109_47# VPWR VPB abpmos
X22 X a_109_47# VPWR VPB abpmos
X23 X a_109_47# VGND VNB abnmos
X24 X a_109_47# VGND VNB abnmos
X25 X a_109_47# VPWR VPB abpmos
X26 X a_109_47# VPWR VPB abpmos
X27 X a_109_47# VPWR VPB abpmos
X28 X a_109_47# VGND VNB abnmos
X29 X a_109_47# VGND VNB abnmos
X30 X a_109_47# VPWR VPB abpmos
X31 X a_109_47# VPWR VPB abpmos
X32 X a_109_47# VPWR VPB abpmos
X33 X a_109_47# VPWR VPB abpmos
X34 X a_109_47# VPWR VPB abpmos
X35 X a_109_47# VPWR VPB abpmos
X36 X a_109_47# VPWR VPB abpmos
X37 X a_109_47# VPWR VPB abpmos
X38 X a_109_47# VPWR VPB abpmos
X39 X a_109_47# VGND VNB abnmos
X40 X a_109_47# VGND VNB abnmos
X41 X a_109_47# VPWR VPB abpmos
X42 X a_109_47# VPWR VPB abpmos
X43 X a_109_47# VPWR VPB abpmos
X44 X a_109_47# VGND VNB abnmos
X45 X a_109_47# VGND VNB abnmos
X46 X a_109_47# VGND VNB abnmos
X47 X a_109_47# VGND VNB abnmos
X48 X a_109_47# VGND VNB abnmos
X49 X a_109_47# VGND VNB abnmos
X50 X a_109_47# VPWR VPB abpmos
X51 X a_109_47# VPWR VPB abpmos
X52 X a_109_47# VPWR VPB abpmos
X53 X a_109_47# VGND VNB abnmos
X54 X a_109_47# VGND VNB abnmos
X55 a_109_47# A VGND VNB abnmos
X56 a_109_47# A VGND VNB abnmos
X57 a_109_47# A VGND VNB abnmos
X58 a_109_47# A VGND VNB abnmos
X59 a_109_47# A VPWR VPB abpmos
X60 a_109_47# A VPWR VPB abpmos
X61 a_109_47# A VPWR VPB abpmos
X62 a_109_47# A VGND VNB abnmos
X63 a_109_47# A VGND VNB abnmos
X64 X a_109_47# VGND VNB abnmos
X65 X a_109_47# VGND VNB abnmos
X66 X a_109_47# VPWR VPB abpmos
X67 X a_109_47# VPWR VPB abpmos
X68 X a_109_47# VPWR VPB abpmos
X69 a_109_47# A VPWR VPB abpmos
X70 a_109_47# A VPWR VPB abpmos
X71 a_109_47# A VPWR VPB abpmos
X72 a_109_47# A VPWR VPB abpmos
X73 a_109_47# A VPWR VPB abpmos
X74 a_109_47# A VPWR VPB abpmos
X75 X a_109_47# VGND VNB abnmos
X76 X a_109_47# VGND VNB abnmos
X77 a_109_47# A VPWR VPB abpmos
X78 a_109_47# A VPWR VPB abpmos
X79 a_109_47# A VPWR VPB abpmos
.ends BUFD12B
