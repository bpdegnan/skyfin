* CLKDLYBUF4S25D1 : abstract conversion of sky130_fd_sc_hd__clkdlybuf4s25_1
* 16 abstract devices (width -> parallel min-width fingers)
.subckt CLKDLYBUF4S25D1 A VGND VPWR X
XCLKDLYBUF4S25D1B A VGND VGND VPWR VPWR X CLKDLYBUF4S25D1B
.ends CLKDLYBUF4S25D1

.subckt CLKDLYBUF4S25D1B A VGND VNB VPB VPWR X
X0 a_355_47# a_244_47# VPWR VPB abpmos
X1 a_355_47# a_244_47# VPWR VPB abpmos
X2 a_244_47# a_27_47# VPWR VPB abpmos
X3 a_244_47# a_27_47# VPWR VPB abpmos
X4 X a_355_47# VPWR VPB abpmos
X5 X a_355_47# VPWR VPB abpmos
X6 X a_355_47# VPWR VPB abpmos
X7 a_27_47# A VPWR VPB abpmos
X8 a_27_47# A VPWR VPB abpmos
X9 a_27_47# A VPWR VPB abpmos
X10 a_355_47# a_244_47# VGND VNB abnmos
X11 a_355_47# a_244_47# VGND VNB abnmos
X12 a_244_47# a_27_47# VGND VNB abnmos
X13 a_244_47# a_27_47# VGND VNB abnmos
X14 X a_355_47# VGND VNB abnmos
X15 a_27_47# A VGND VNB abnmos
.ends CLKDLYBUF4S25D1B
