* A211OID2 : abstract conversion of sky130_fd_sc_hd__a211oi_2
* 40 abstract devices (width -> parallel min-width fingers)
.subckt A211OID2 A1 A2 B1 C1 VGND VPWR Y
XA211OID2B A1 A2 B1 C1 VGND VGND VPWR VPWR Y A211OID2B
.ends A211OID2

.subckt A211OID2B A1 A2 B1 C1 VGND VNB VPB VPWR Y
X0 a_292_297# B1 a_37_297# VPB abpmos
X1 a_292_297# B1 a_37_297# VPB abpmos
X2 a_292_297# B1 a_37_297# VPB abpmos
X3 Y C1 VGND VNB abnmos
X4 Y C1 VGND VNB abnmos
X5 a_37_297# B1 a_292_297# VPB abpmos
X6 a_37_297# B1 a_292_297# VPB abpmos
X7 a_37_297# B1 a_292_297# VPB abpmos
X8 a_292_297# A2 VPWR VPB abpmos
X9 a_292_297# A2 VPWR VPB abpmos
X10 a_292_297# A2 VPWR VPB abpmos
X11 a_485_47# A2 VGND VNB abnmos
X12 a_485_47# A2 VGND VNB abnmos
X13 a_485_47# A1 Y VNB abnmos
X14 a_485_47# A1 Y VNB abnmos
X15 Y A1 a_485_47# VNB abnmos
X16 Y A1 a_485_47# VNB abnmos
X17 a_485_47# A2 VGND VNB abnmos
X18 a_485_47# A2 VGND VNB abnmos
X19 Y C1 VGND VNB abnmos
X20 Y C1 VGND VNB abnmos
X21 Y B1 VGND VNB abnmos
X22 Y B1 VGND VNB abnmos
X23 a_292_297# A1 VPWR VPB abpmos
X24 a_292_297# A1 VPWR VPB abpmos
X25 a_292_297# A1 VPWR VPB abpmos
X26 a_292_297# A2 VPWR VPB abpmos
X27 a_292_297# A2 VPWR VPB abpmos
X28 a_292_297# A2 VPWR VPB abpmos
X29 Y C1 a_37_297# VPB abpmos
X30 Y C1 a_37_297# VPB abpmos
X31 Y C1 a_37_297# VPB abpmos
X32 a_37_297# C1 Y VPB abpmos
X33 a_37_297# C1 Y VPB abpmos
X34 a_37_297# C1 Y VPB abpmos
X35 Y B1 VGND VNB abnmos
X36 Y B1 VGND VNB abnmos
X37 a_292_297# A1 VPWR VPB abpmos
X38 a_292_297# A1 VPWR VPB abpmos
X39 a_292_297# A1 VPWR VPB abpmos
.ends A211OID2B
