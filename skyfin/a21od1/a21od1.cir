* A21OD1 : abstract conversion of sky130_fd_sc_hd__a21o_1
* 20 abstract devices (width -> parallel min-width fingers)
.subckt A21OD1 A1 A2 B1 VGND VPWR X
XA21OD1B A1 A2 B1 VGND VGND VPWR VPWR X A21OD1B
.ends A21OD1

.subckt A21OD1B A1 A2 B1 VGND VNB VPB VPWR X
X0 a_384_47# A2 VGND VNB abnmos
X1 a_384_47# A2 VGND VNB abnmos
X2 X a_81_21# VPWR VPB abpmos
X3 X a_81_21# VPWR VPB abpmos
X4 X a_81_21# VPWR VPB abpmos
X5 a_81_21# B1 a_299_297# VPB abpmos
X6 a_81_21# B1 a_299_297# VPB abpmos
X7 a_81_21# B1 a_299_297# VPB abpmos
X8 a_81_21# B1 VGND VNB abnmos
X9 a_81_21# B1 VGND VNB abnmos
X10 a_299_297# A1 VPWR VPB abpmos
X11 a_299_297# A1 VPWR VPB abpmos
X12 a_299_297# A1 VPWR VPB abpmos
X13 a_299_297# A2 VPWR VPB abpmos
X14 a_299_297# A2 VPWR VPB abpmos
X15 a_299_297# A2 VPWR VPB abpmos
X16 X a_81_21# VGND VNB abnmos
X17 X a_81_21# VGND VNB abnmos
X18 a_81_21# A1 a_384_47# VNB abnmos
X19 a_81_21# A1 a_384_47# VNB abnmos
.ends A21OD1B
