* LPFLOW_CLKBUFKAPWRD4 : abstract conversion of sky130_fd_sc_hd__lpflow_clkbufkapwr_4
* 20 abstract devices (width -> parallel min-width fingers) ; secondary power ['KAPWR'] collapsed onto VPWR
.subckt LPFLOW_CLKBUFKAPWRD4 A VGND VPWR X
XLPFLOW_CLKBUFKAPWRD4B A VPWR VGND VGND VPWR VPWR X LPFLOW_CLKBUFKAPWRD4B
.ends LPFLOW_CLKBUFKAPWRD4

.subckt LPFLOW_CLKBUFKAPWRD4B A KAPWR VGND VNB VPB VPWR X
X0 KAPWR a_27_47# X VPB abpmos
X1 KAPWR a_27_47# X VPB abpmos
X2 KAPWR a_27_47# X VPB abpmos
X3 X a_27_47# KAPWR VPB abpmos
X4 X a_27_47# KAPWR VPB abpmos
X5 X a_27_47# KAPWR VPB abpmos
X6 a_27_47# A KAPWR VPB abpmos
X7 a_27_47# A KAPWR VPB abpmos
X8 a_27_47# A KAPWR VPB abpmos
X9 a_27_47# A VGND VNB abnmos
X10 X a_27_47# KAPWR VPB abpmos
X11 X a_27_47# KAPWR VPB abpmos
X12 X a_27_47# KAPWR VPB abpmos
X13 X a_27_47# VGND VNB abnmos
X14 X a_27_47# VGND VNB abnmos
X15 X a_27_47# VGND VNB abnmos
X16 X a_27_47# VGND VNB abnmos
X17 KAPWR a_27_47# X VPB abpmos
X18 KAPWR a_27_47# X VPB abpmos
X19 KAPWR a_27_47# X VPB abpmos
.ends LPFLOW_CLKBUFKAPWRD4B
