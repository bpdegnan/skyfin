* NOR4BBD4 : abstract conversion of sky130_fd_sc_hd__nor4bb_4
* 90 abstract devices (width -> parallel min-width fingers)
.subckt NOR4BBD4 A B C_N D_N VGND VPWR Y
XNOR4BBD4B A B C_N D_N VGND VGND VPWR VPWR Y NOR4BBD4B
.ends NOR4BBD4

.subckt NOR4BBD4B A B C_N D_N VGND VNB VPB VPWR Y
X0 a_729_297# B a_1087_297# VPB abpmos
X1 a_729_297# B a_1087_297# VPB abpmos
X2 a_729_297# B a_1087_297# VPB abpmos
X3 Y a_197_47# VGND VNB abnmos
X4 Y a_197_47# VGND VNB abnmos
X5 a_197_47# D_N VPWR VPB abpmos
X6 a_197_47# D_N VPWR VPB abpmos
X7 a_197_47# D_N VPWR VPB abpmos
X8 Y A VGND VNB abnmos
X9 Y A VGND VNB abnmos
X10 Y a_197_47# a_311_297# VPB abpmos
X11 Y a_197_47# a_311_297# VPB abpmos
X12 Y a_197_47# a_311_297# VPB abpmos
X13 Y a_197_47# a_311_297# VPB abpmos
X14 Y a_197_47# a_311_297# VPB abpmos
X15 Y a_197_47# a_311_297# VPB abpmos
X16 Y a_27_297# VGND VNB abnmos
X17 Y a_27_297# VGND VNB abnmos
X18 Y A VGND VNB abnmos
X19 Y A VGND VNB abnmos
X20 a_1087_297# A VPWR VPB abpmos
X21 a_1087_297# A VPWR VPB abpmos
X22 a_1087_297# A VPWR VPB abpmos
X23 a_27_297# C_N VPWR VPB abpmos
X24 a_27_297# C_N VPWR VPB abpmos
X25 a_27_297# C_N VPWR VPB abpmos
X26 a_1087_297# A VPWR VPB abpmos
X27 a_1087_297# A VPWR VPB abpmos
X28 a_1087_297# A VPWR VPB abpmos
X29 Y B VGND VNB abnmos
X30 Y B VGND VNB abnmos
X31 a_311_297# a_197_47# Y VPB abpmos
X32 a_311_297# a_197_47# Y VPB abpmos
X33 a_311_297# a_197_47# Y VPB abpmos
X34 a_27_297# C_N VGND VNB abnmos
X35 a_27_297# C_N VGND VNB abnmos
X36 a_311_297# a_197_47# Y VPB abpmos
X37 a_311_297# a_197_47# Y VPB abpmos
X38 a_311_297# a_197_47# Y VPB abpmos
X39 Y a_27_297# VGND VNB abnmos
X40 Y a_27_297# VGND VNB abnmos
X41 Y B VGND VNB abnmos
X42 Y B VGND VNB abnmos
X43 a_1087_297# A VPWR VPB abpmos
X44 a_1087_297# A VPWR VPB abpmos
X45 a_1087_297# A VPWR VPB abpmos
X46 Y a_197_47# VGND VNB abnmos
X47 Y a_197_47# VGND VNB abnmos
X48 a_1087_297# A VPWR VPB abpmos
X49 a_1087_297# A VPWR VPB abpmos
X50 a_1087_297# A VPWR VPB abpmos
X51 Y B VGND VNB abnmos
X52 Y B VGND VNB abnmos
X53 a_729_297# B a_1087_297# VPB abpmos
X54 a_729_297# B a_1087_297# VPB abpmos
X55 a_729_297# B a_1087_297# VPB abpmos
X56 a_197_47# D_N VGND VNB abnmos
X57 a_197_47# D_N VGND VNB abnmos
X58 Y a_197_47# VGND VNB abnmos
X59 Y a_197_47# VGND VNB abnmos
X60 a_311_297# a_27_297# a_729_297# VPB abpmos
X61 a_311_297# a_27_297# a_729_297# VPB abpmos
X62 a_311_297# a_27_297# a_729_297# VPB abpmos
X63 Y A VGND VNB abnmos
X64 Y A VGND VNB abnmos
X65 a_311_297# a_27_297# a_729_297# VPB abpmos
X66 a_311_297# a_27_297# a_729_297# VPB abpmos
X67 a_311_297# a_27_297# a_729_297# VPB abpmos
X68 Y a_27_297# VGND VNB abnmos
X69 Y a_27_297# VGND VNB abnmos
X70 Y A VGND VNB abnmos
X71 Y A VGND VNB abnmos
X72 a_729_297# a_27_297# a_311_297# VPB abpmos
X73 a_729_297# a_27_297# a_311_297# VPB abpmos
X74 a_729_297# a_27_297# a_311_297# VPB abpmos
X75 Y B VGND VNB abnmos
X76 Y B VGND VNB abnmos
X77 a_729_297# a_27_297# a_311_297# VPB abpmos
X78 a_729_297# a_27_297# a_311_297# VPB abpmos
X79 a_729_297# a_27_297# a_311_297# VPB abpmos
X80 a_1087_297# B a_729_297# VPB abpmos
X81 a_1087_297# B a_729_297# VPB abpmos
X82 a_1087_297# B a_729_297# VPB abpmos
X83 a_1087_297# B a_729_297# VPB abpmos
X84 a_1087_297# B a_729_297# VPB abpmos
X85 a_1087_297# B a_729_297# VPB abpmos
X86 Y a_27_297# VGND VNB abnmos
X87 Y a_27_297# VGND VNB abnmos
X88 Y a_197_47# VGND VNB abnmos
X89 Y a_197_47# VGND VNB abnmos
.ends NOR4BBD4B
