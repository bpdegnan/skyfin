* LPFLOW_CLKINVKAPWRD4 : abstract conversion of sky130_fd_sc_hd__lpflow_clkinvkapwr_4
* 22 abstract devices (width -> parallel min-width fingers) ; secondary power ['KAPWR'] collapsed onto VPWR
.subckt LPFLOW_CLKINVKAPWRD4 A VGND VPWR Y
XLPFLOW_CLKINVKAPWRD4B A VPWR VGND VGND VPWR VPWR Y LPFLOW_CLKINVKAPWRD4B
.ends LPFLOW_CLKINVKAPWRD4

.subckt LPFLOW_CLKINVKAPWRD4B A KAPWR VGND VNB VPB VPWR Y
X0 KAPWR A Y VPB abpmos
X1 KAPWR A Y VPB abpmos
X2 KAPWR A Y VPB abpmos
X3 Y A KAPWR VPB abpmos
X4 Y A KAPWR VPB abpmos
X5 Y A KAPWR VPB abpmos
X6 Y A VGND VNB abnmos
X7 Y A VGND VNB abnmos
X8 Y A VGND VNB abnmos
X9 KAPWR A Y VPB abpmos
X10 KAPWR A Y VPB abpmos
X11 KAPWR A Y VPB abpmos
X12 Y A VGND VNB abnmos
X13 Y A KAPWR VPB abpmos
X14 Y A KAPWR VPB abpmos
X15 Y A KAPWR VPB abpmos
X16 Y A KAPWR VPB abpmos
X17 Y A KAPWR VPB abpmos
X18 Y A KAPWR VPB abpmos
X19 KAPWR A Y VPB abpmos
X20 KAPWR A Y VPB abpmos
X21 KAPWR A Y VPB abpmos
.ends LPFLOW_CLKINVKAPWRD4B
