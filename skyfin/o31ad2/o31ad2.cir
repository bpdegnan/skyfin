* O31AD2 : abstract conversion of sky130_fd_sc_hd__o31a_2
* 30 abstract devices (width -> parallel min-width fingers)
.subckt O31AD2 A1 A2 A3 B1 VGND VPWR X
XO31AD2B A1 A2 A3 B1 VGND VGND VPWR VPWR X O31AD2B
.ends O31AD2

.subckt O31AD2B A1 A2 A3 B1 VGND VNB VPB VPWR X
X0 a_430_297# A3 a_108_21# VPB abpmos
X1 a_430_297# A3 a_108_21# VPB abpmos
X2 a_430_297# A3 a_108_21# VPB abpmos
X3 X a_108_21# VGND VNB abnmos
X4 X a_108_21# VGND VNB abnmos
X5 a_108_21# B1 VPWR VPB abpmos
X6 a_108_21# B1 VPWR VPB abpmos
X7 a_108_21# B1 VPWR VPB abpmos
X8 a_346_47# A1 VGND VNB abnmos
X9 a_346_47# A1 VGND VNB abnmos
X10 a_346_47# B1 a_108_21# VNB abnmos
X11 a_346_47# B1 a_108_21# VNB abnmos
X12 a_346_47# A3 VGND VNB abnmos
X13 a_346_47# A3 VGND VNB abnmos
X14 X a_108_21# VGND VNB abnmos
X15 X a_108_21# VGND VNB abnmos
X16 X a_108_21# VPWR VPB abpmos
X17 X a_108_21# VPWR VPB abpmos
X18 X a_108_21# VPWR VPB abpmos
X19 a_346_297# A1 VPWR VPB abpmos
X20 a_346_297# A1 VPWR VPB abpmos
X21 a_346_297# A1 VPWR VPB abpmos
X22 X a_108_21# VPWR VPB abpmos
X23 X a_108_21# VPWR VPB abpmos
X24 X a_108_21# VPWR VPB abpmos
X25 a_346_47# A2 VGND VNB abnmos
X26 a_346_47# A2 VGND VNB abnmos
X27 a_346_297# A2 a_430_297# VPB abpmos
X28 a_346_297# A2 a_430_297# VPB abpmos
X29 a_346_297# A2 a_430_297# VPB abpmos
.ends O31AD2B
