* BUFBUFD16 : abstract conversion of sky130_fd_sc_hd__bufbuf_16
* 130 abstract devices (width -> parallel min-width fingers)
.subckt BUFBUFD16 A VGND VPWR X
XBUFBUFD16B A VGND VGND VPWR VPWR X BUFBUFD16B
.ends BUFBUFD16

.subckt BUFBUFD16B A VGND VNB VPB VPWR X
X0 X a_549_47# VPWR VPB abpmos
X1 X a_549_47# VPWR VPB abpmos
X2 X a_549_47# VPWR VPB abpmos
X3 a_549_47# a_215_47# VGND VNB abnmos
X4 a_549_47# a_215_47# VGND VNB abnmos
X5 X a_549_47# VPWR VPB abpmos
X6 X a_549_47# VPWR VPB abpmos
X7 X a_549_47# VPWR VPB abpmos
X8 X a_549_47# VGND VNB abnmos
X9 X a_549_47# VGND VNB abnmos
X10 X a_549_47# VPWR VPB abpmos
X11 X a_549_47# VPWR VPB abpmos
X12 X a_549_47# VPWR VPB abpmos
X13 X a_549_47# VGND VNB abnmos
X14 X a_549_47# VGND VNB abnmos
X15 X a_549_47# VGND VNB abnmos
X16 X a_549_47# VGND VNB abnmos
X17 a_549_47# a_215_47# VGND VNB abnmos
X18 a_549_47# a_215_47# VGND VNB abnmos
X19 X a_549_47# VPWR VPB abpmos
X20 X a_549_47# VPWR VPB abpmos
X21 X a_549_47# VPWR VPB abpmos
X22 a_215_47# a_109_47# VGND VNB abnmos
X23 a_215_47# a_109_47# VGND VNB abnmos
X24 a_549_47# a_215_47# VGND VNB abnmos
X25 a_549_47# a_215_47# VGND VNB abnmos
X26 a_549_47# a_215_47# VPWR VPB abpmos
X27 a_549_47# a_215_47# VPWR VPB abpmos
X28 a_549_47# a_215_47# VPWR VPB abpmos
X29 X a_549_47# VGND VNB abnmos
X30 X a_549_47# VGND VNB abnmos
X31 X a_549_47# VPWR VPB abpmos
X32 X a_549_47# VPWR VPB abpmos
X33 X a_549_47# VPWR VPB abpmos
X34 X a_549_47# VGND VNB abnmos
X35 X a_549_47# VGND VNB abnmos
X36 a_215_47# a_109_47# VPWR VPB abpmos
X37 a_215_47# a_109_47# VPWR VPB abpmos
X38 a_215_47# a_109_47# VPWR VPB abpmos
X39 X a_549_47# VPWR VPB abpmos
X40 X a_549_47# VPWR VPB abpmos
X41 X a_549_47# VPWR VPB abpmos
X42 X a_549_47# VPWR VPB abpmos
X43 X a_549_47# VPWR VPB abpmos
X44 X a_549_47# VPWR VPB abpmos
X45 a_215_47# a_109_47# VPWR VPB abpmos
X46 a_215_47# a_109_47# VPWR VPB abpmos
X47 a_215_47# a_109_47# VPWR VPB abpmos
X48 a_549_47# a_215_47# VPWR VPB abpmos
X49 a_549_47# a_215_47# VPWR VPB abpmos
X50 a_549_47# a_215_47# VPWR VPB abpmos
X51 X a_549_47# VPWR VPB abpmos
X52 X a_549_47# VPWR VPB abpmos
X53 X a_549_47# VPWR VPB abpmos
X54 X a_549_47# VGND VNB abnmos
X55 X a_549_47# VGND VNB abnmos
X56 X a_549_47# VPWR VPB abpmos
X57 X a_549_47# VPWR VPB abpmos
X58 X a_549_47# VPWR VPB abpmos
X59 X a_549_47# VPWR VPB abpmos
X60 X a_549_47# VPWR VPB abpmos
X61 X a_549_47# VPWR VPB abpmos
X62 a_215_47# a_109_47# VPWR VPB abpmos
X63 a_215_47# a_109_47# VPWR VPB abpmos
X64 a_215_47# a_109_47# VPWR VPB abpmos
X65 a_549_47# a_215_47# VGND VNB abnmos
X66 a_549_47# a_215_47# VGND VNB abnmos
X67 X a_549_47# VPWR VPB abpmos
X68 X a_549_47# VPWR VPB abpmos
X69 X a_549_47# VPWR VPB abpmos
X70 X a_549_47# VGND VNB abnmos
X71 X a_549_47# VGND VNB abnmos
X72 X a_549_47# VPWR VPB abpmos
X73 X a_549_47# VPWR VPB abpmos
X74 X a_549_47# VPWR VPB abpmos
X75 a_549_47# a_215_47# VGND VNB abnmos
X76 a_549_47# a_215_47# VGND VNB abnmos
X77 X a_549_47# VGND VNB abnmos
X78 X a_549_47# VGND VNB abnmos
X79 X a_549_47# VGND VNB abnmos
X80 X a_549_47# VGND VNB abnmos
X81 a_549_47# a_215_47# VPWR VPB abpmos
X82 a_549_47# a_215_47# VPWR VPB abpmos
X83 a_549_47# a_215_47# VPWR VPB abpmos
X84 a_215_47# a_109_47# VGND VNB abnmos
X85 a_215_47# a_109_47# VGND VNB abnmos
X86 X a_549_47# VGND VNB abnmos
X87 X a_549_47# VGND VNB abnmos
X88 X a_549_47# VPWR VPB abpmos
X89 X a_549_47# VPWR VPB abpmos
X90 X a_549_47# VPWR VPB abpmos
X91 X a_549_47# VGND VNB abnmos
X92 X a_549_47# VGND VNB abnmos
X93 a_549_47# a_215_47# VPWR VPB abpmos
X94 a_549_47# a_215_47# VPWR VPB abpmos
X95 a_549_47# a_215_47# VPWR VPB abpmos
X96 a_109_47# A VGND VNB abnmos
X97 a_109_47# A VGND VNB abnmos
X98 a_549_47# a_215_47# VPWR VPB abpmos
X99 a_549_47# a_215_47# VPWR VPB abpmos
X100 a_549_47# a_215_47# VPWR VPB abpmos
X101 X a_549_47# VGND VNB abnmos
X102 X a_549_47# VGND VNB abnmos
X103 a_109_47# A VPWR VPB abpmos
X104 a_109_47# A VPWR VPB abpmos
X105 a_109_47# A VPWR VPB abpmos
X106 X a_549_47# VPWR VPB abpmos
X107 X a_549_47# VPWR VPB abpmos
X108 X a_549_47# VPWR VPB abpmos
X109 a_215_47# a_109_47# VGND VNB abnmos
X110 a_215_47# a_109_47# VGND VNB abnmos
X111 X a_549_47# VPWR VPB abpmos
X112 X a_549_47# VPWR VPB abpmos
X113 X a_549_47# VPWR VPB abpmos
X114 a_549_47# a_215_47# VGND VNB abnmos
X115 a_549_47# a_215_47# VGND VNB abnmos
X116 X a_549_47# VGND VNB abnmos
X117 X a_549_47# VGND VNB abnmos
X118 a_549_47# a_215_47# VPWR VPB abpmos
X119 a_549_47# a_215_47# VPWR VPB abpmos
X120 a_549_47# a_215_47# VPWR VPB abpmos
X121 X a_549_47# VGND VNB abnmos
X122 X a_549_47# VGND VNB abnmos
X123 X a_549_47# VGND VNB abnmos
X124 X a_549_47# VGND VNB abnmos
X125 X a_549_47# VPWR VPB abpmos
X126 X a_549_47# VPWR VPB abpmos
X127 X a_549_47# VPWR VPB abpmos
X128 X a_549_47# VGND VNB abnmos
X129 X a_549_47# VGND VNB abnmos
.ends BUFBUFD16B
