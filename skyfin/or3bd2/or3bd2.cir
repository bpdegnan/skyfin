* OR3BD2 : abstract conversion of sky130_fd_sc_hd__or3b_2
* 18 abstract devices (width -> parallel min-width fingers)
.subckt OR3BD2 A B C_N VGND VPWR X
XOR3BD2B A B C_N VGND VGND VPWR VPWR X OR3BD2B
.ends OR3BD2

.subckt OR3BD2B A B C_N VGND VNB VPB VPWR X
X0 a_176_21# a_27_47# VGND VNB abnmos
X1 a_176_21# B VGND VNB abnmos
X2 X a_176_21# VGND VNB abnmos
X3 X a_176_21# VGND VNB abnmos
X4 a_27_47# C_N VPWR VPB abpmos
X5 a_176_21# A VGND VNB abnmos
X6 X a_176_21# VGND VNB abnmos
X7 X a_176_21# VGND VNB abnmos
X8 a_27_47# C_N VGND VNB abnmos
X9 X a_176_21# VPWR VPB abpmos
X10 X a_176_21# VPWR VPB abpmos
X11 X a_176_21# VPWR VPB abpmos
X12 a_388_297# A VPWR VPB abpmos
X13 a_472_297# a_27_47# a_176_21# VPB abpmos
X14 X a_176_21# VPWR VPB abpmos
X15 X a_176_21# VPWR VPB abpmos
X16 X a_176_21# VPWR VPB abpmos
X17 a_388_297# B a_472_297# VPB abpmos
.ends OR3BD2B
