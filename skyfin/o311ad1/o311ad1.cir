* O311AD1 : abstract conversion of sky130_fd_sc_hd__o311a_1
* 30 abstract devices (width -> parallel min-width fingers)
.subckt O311AD1 A1 A2 A3 B1 C1 VGND VPWR X
XO311AD1B A1 A2 A3 B1 C1 VGND VGND VPWR VPWR X O311AD1B
.ends O311AD1

.subckt O311AD1B A1 A2 A3 B1 C1 VGND VNB VPB VPWR X
X0 a_266_47# B1 a_585_47# VNB abnmos
X1 a_266_47# B1 a_585_47# VNB abnmos
X2 a_266_47# A1 VGND VNB abnmos
X3 a_266_47# A1 VGND VNB abnmos
X4 a_81_21# C1 VPWR VPB abpmos
X5 a_81_21# C1 VPWR VPB abpmos
X6 a_81_21# C1 VPWR VPB abpmos
X7 a_266_47# A2 VGND VNB abnmos
X8 a_266_47# A2 VGND VNB abnmos
X9 X a_81_21# VPWR VPB abpmos
X10 X a_81_21# VPWR VPB abpmos
X11 X a_81_21# VPWR VPB abpmos
X12 a_266_47# A3 VGND VNB abnmos
X13 a_266_47# A3 VGND VNB abnmos
X14 a_266_297# A2 a_368_297# VPB abpmos
X15 a_266_297# A2 a_368_297# VPB abpmos
X16 a_266_297# A2 a_368_297# VPB abpmos
X17 a_81_21# B1 VPWR VPB abpmos
X18 a_81_21# B1 VPWR VPB abpmos
X19 a_81_21# B1 VPWR VPB abpmos
X20 a_585_47# C1 a_81_21# VNB abnmos
X21 a_585_47# C1 a_81_21# VNB abnmos
X22 a_368_297# A3 a_81_21# VPB abpmos
X23 a_368_297# A3 a_81_21# VPB abpmos
X24 a_368_297# A3 a_81_21# VPB abpmos
X25 a_266_297# A1 VPWR VPB abpmos
X26 a_266_297# A1 VPWR VPB abpmos
X27 a_266_297# A1 VPWR VPB abpmos
X28 X a_81_21# VGND VNB abnmos
X29 X a_81_21# VGND VNB abnmos
.ends O311AD1B
