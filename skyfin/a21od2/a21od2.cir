* A21OD2 : abstract conversion of sky130_fd_sc_hd__a21o_2
* 25 abstract devices (width -> parallel min-width fingers)
.subckt A21OD2 A1 A2 B1 VGND VPWR X
XA21OD2B A1 A2 B1 VGND VGND VPWR VPWR X A21OD2B
.ends A21OD2

.subckt A21OD2B A1 A2 B1 VGND VNB VPB VPWR X
X0 a_80_199# A1 a_458_47# VNB abnmos
X1 a_80_199# A1 a_458_47# VNB abnmos
X2 X a_80_199# VPWR VPB abpmos
X3 X a_80_199# VPWR VPB abpmos
X4 X a_80_199# VPWR VPB abpmos
X5 X a_80_199# VPWR VPB abpmos
X6 X a_80_199# VPWR VPB abpmos
X7 X a_80_199# VPWR VPB abpmos
X8 X a_80_199# VGND VNB abnmos
X9 X a_80_199# VGND VNB abnmos
X10 a_80_199# B1 VGND VNB abnmos
X11 a_80_199# B1 VGND VNB abnmos
X12 X a_80_199# VGND VNB abnmos
X13 X a_80_199# VGND VNB abnmos
X14 a_386_297# A2 VPWR VPB abpmos
X15 a_386_297# A2 VPWR VPB abpmos
X16 a_386_297# A2 VPWR VPB abpmos
X17 a_458_47# A2 VGND VNB abnmos
X18 a_458_47# A2 VGND VNB abnmos
X19 a_80_199# B1 a_386_297# VPB abpmos
X20 a_80_199# B1 a_386_297# VPB abpmos
X21 a_80_199# B1 a_386_297# VPB abpmos
X22 a_386_297# A1 VPWR VPB abpmos
X23 a_386_297# A1 VPWR VPB abpmos
X24 a_386_297# A1 VPWR VPB abpmos
.ends A21OD2B
