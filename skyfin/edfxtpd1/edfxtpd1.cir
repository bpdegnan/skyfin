* EDFXTPD1 : abstract conversion of sky130_fd_sc_hd__edfxtp_1
* 47 abstract devices (width -> parallel min-width fingers)
.subckt EDFXTPD1 CLK D DE VGND VPWR Q
XEDFXTPD1B CLK D DE VGND VGND VPWR VPWR Q EDFXTPD1B
.ends EDFXTPD1

.subckt EDFXTPD1B CLK D DE VGND VNB VPB VPWR Q
X0 a_986_413# a_27_47# a_1077_413# VPB abpmos
X1 a_791_264# a_1591_413# VGND VNB abnmos
X2 a_729_47# a_791_264# a_299_47# VNB abnmos
X3 a_791_264# a_1591_413# VPWR VPB abpmos
X4 a_791_264# a_1591_413# VPWR VPB abpmos
X5 a_1150_159# a_986_413# VGND VNB abnmos
X6 a_1150_159# a_986_413# VGND VNB abnmos
X7 a_299_47# D a_381_369# VPB abpmos
X8 a_299_47# D a_381_369# VPB abpmos
X9 a_381_369# a_423_343# VPWR VPB abpmos
X10 a_381_369# a_423_343# VPWR VPB abpmos
X11 a_1591_413# a_193_47# a_1675_413# VPB abpmos
X12 a_1514_47# a_1150_159# VGND VNB abnmos
X13 Q a_1591_413# VGND VNB abnmos
X14 Q a_1591_413# VGND VNB abnmos
X15 a_729_369# DE VPWR VPB abpmos
X16 a_729_369# DE VPWR VPB abpmos
X17 a_1150_159# a_986_413# VPWR VPB abpmos
X18 a_1150_159# a_986_413# VPWR VPB abpmos
X19 a_381_47# DE VGND VNB abnmos
X20 a_1500_413# a_27_47# a_1591_413# VPB abpmos
X21 a_1675_413# a_791_264# VPWR VPB abpmos
X22 a_729_369# a_791_264# a_299_47# VPB abpmos
X23 a_729_369# a_791_264# a_299_47# VPB abpmos
X24 a_423_343# DE VGND VNB abnmos
X25 a_1101_47# a_1150_159# VGND VNB abnmos
X26 a_1077_413# a_1150_159# VPWR VPB abpmos
X27 a_193_47# a_27_47# VGND VNB abnmos
X28 a_299_47# a_27_47# a_986_413# VNB abnmos
X29 a_27_47# CLK VGND VNB abnmos
X30 a_729_47# a_423_343# VGND VNB abnmos
X31 a_986_413# a_193_47# a_1101_47# VNB abnmos
X32 a_27_47# CLK VPWR VPB abpmos
X33 a_27_47# CLK VPWR VPB abpmos
X34 a_1591_413# a_27_47# a_1717_47# VNB abnmos
X35 a_193_47# a_27_47# VPWR VPB abpmos
X36 a_193_47# a_27_47# VPWR VPB abpmos
X37 a_299_47# a_193_47# a_986_413# VPB abpmos
X38 a_299_47# D a_381_47# VNB abnmos
X39 a_423_343# DE VPWR VPB abpmos
X40 a_423_343# DE VPWR VPB abpmos
X41 a_1514_47# a_193_47# a_1591_413# VNB abnmos
X42 Q a_1591_413# VPWR VPB abpmos
X43 Q a_1591_413# VPWR VPB abpmos
X44 Q a_1591_413# VPWR VPB abpmos
X45 a_1500_413# a_1150_159# VPWR VPB abpmos
X46 a_1717_47# a_791_264# VGND VNB abnmos
.ends EDFXTPD1B
