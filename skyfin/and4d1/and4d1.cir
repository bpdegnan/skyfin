* AND4D1 : abstract conversion of sky130_fd_sc_hd__and4_1
* 13 abstract devices (width -> parallel min-width fingers)
.subckt AND4D1 A B C D VGND VPWR X
XAND4D1B A B C D VGND VGND VPWR VPWR X AND4D1B
.ends AND4D1

.subckt AND4D1B A B C D VGND VNB VPB VPWR X
X0 a_197_47# C a_303_47# VNB abnmos
X1 a_303_47# D VGND VNB abnmos
X2 X a_27_47# VGND VNB abnmos
X3 X a_27_47# VGND VNB abnmos
X4 a_27_47# D VPWR VPB abpmos
X5 a_27_47# C VPWR VPB abpmos
X6 a_109_47# B a_197_47# VNB abnmos
X7 X a_27_47# VPWR VPB abpmos
X8 X a_27_47# VPWR VPB abpmos
X9 X a_27_47# VPWR VPB abpmos
X10 a_27_47# A VPWR VPB abpmos
X11 a_27_47# B VPWR VPB abpmos
X12 a_27_47# A a_109_47# VNB abnmos
.ends AND4D1B
