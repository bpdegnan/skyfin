* O221AD4 : abstract conversion of sky130_fd_sc_hd__o221a_4
* 70 abstract devices (width -> parallel min-width fingers)
.subckt O221AD4 A1 A2 B1 B2 C1 VGND VPWR X
XO221AD4B A1 A2 B1 B2 C1 VGND VGND VPWR VPWR X O221AD4B
.ends O221AD4

.subckt O221AD4B A1 A2 B1 B2 C1 VGND VNB VPB VPWR X
X0 a_277_47# A2 VGND VNB abnmos
X1 a_277_47# A2 VGND VNB abnmos
X2 X a_109_47# VGND VNB abnmos
X3 X a_109_47# VGND VNB abnmos
X4 a_27_47# B2 a_277_47# VNB abnmos
X5 a_27_47# B2 a_277_47# VNB abnmos
X6 X a_109_47# VPWR VPB abpmos
X7 X a_109_47# VPWR VPB abpmos
X8 X a_109_47# VPWR VPB abpmos
X9 X a_109_47# VGND VNB abnmos
X10 X a_109_47# VGND VNB abnmos
X11 a_277_297# B1 VPWR VPB abpmos
X12 a_277_297# B1 VPWR VPB abpmos
X13 a_277_297# B1 VPWR VPB abpmos
X14 a_277_47# A2 VGND VNB abnmos
X15 a_277_47# A2 VGND VNB abnmos
X16 a_277_47# B2 a_27_47# VNB abnmos
X17 a_277_47# B2 a_27_47# VNB abnmos
X18 a_277_47# B1 a_27_47# VNB abnmos
X19 a_277_47# B1 a_27_47# VNB abnmos
X20 X a_109_47# VPWR VPB abpmos
X21 X a_109_47# VPWR VPB abpmos
X22 X a_109_47# VPWR VPB abpmos
X23 a_277_47# A1 VGND VNB abnmos
X24 a_277_47# A1 VGND VNB abnmos
X25 X a_109_47# VPWR VPB abpmos
X26 X a_109_47# VPWR VPB abpmos
X27 X a_109_47# VPWR VPB abpmos
X28 a_27_47# B1 a_277_47# VNB abnmos
X29 a_27_47# B1 a_277_47# VNB abnmos
X30 a_717_297# A1 VPWR VPB abpmos
X31 a_717_297# A1 VPWR VPB abpmos
X32 a_717_297# A1 VPWR VPB abpmos
X33 a_109_47# C1 a_27_47# VNB abnmos
X34 a_109_47# C1 a_27_47# VNB abnmos
X35 a_277_297# B1 VPWR VPB abpmos
X36 a_277_297# B1 VPWR VPB abpmos
X37 a_277_297# B1 VPWR VPB abpmos
X38 a_717_297# A1 VPWR VPB abpmos
X39 a_717_297# A1 VPWR VPB abpmos
X40 a_717_297# A1 VPWR VPB abpmos
X41 a_27_47# C1 a_109_47# VNB abnmos
X42 a_27_47# C1 a_109_47# VNB abnmos
X43 a_109_47# A2 a_717_297# VPB abpmos
X44 a_109_47# A2 a_717_297# VPB abpmos
X45 a_109_47# A2 a_717_297# VPB abpmos
X46 a_109_47# B2 a_277_297# VPB abpmos
X47 a_109_47# B2 a_277_297# VPB abpmos
X48 a_109_47# B2 a_277_297# VPB abpmos
X49 a_109_47# C1 VPWR VPB abpmos
X50 a_109_47# C1 VPWR VPB abpmos
X51 a_109_47# C1 VPWR VPB abpmos
X52 a_109_47# C1 VPWR VPB abpmos
X53 a_109_47# C1 VPWR VPB abpmos
X54 a_109_47# C1 VPWR VPB abpmos
X55 a_277_47# A1 VGND VNB abnmos
X56 a_277_47# A1 VGND VNB abnmos
X57 a_717_297# A2 a_109_47# VPB abpmos
X58 a_717_297# A2 a_109_47# VPB abpmos
X59 a_717_297# A2 a_109_47# VPB abpmos
X60 X a_109_47# VGND VNB abnmos
X61 X a_109_47# VGND VNB abnmos
X62 a_277_297# B2 a_109_47# VPB abpmos
X63 a_277_297# B2 a_109_47# VPB abpmos
X64 a_277_297# B2 a_109_47# VPB abpmos
X65 X a_109_47# VPWR VPB abpmos
X66 X a_109_47# VPWR VPB abpmos
X67 X a_109_47# VPWR VPB abpmos
X68 X a_109_47# VGND VNB abnmos
X69 X a_109_47# VGND VNB abnmos
.ends O221AD4B
