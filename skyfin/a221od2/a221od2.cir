* A221OD2 : abstract conversion of sky130_fd_sc_hd__a221o_2
* 35 abstract devices (width -> parallel min-width fingers)
.subckt A221OD2 A1 A2 B1 B2 C1 VGND VPWR X
XA221OD2B A1 A2 B1 B2 C1 VGND VGND VPWR VPWR X A221OD2B
.ends A221OD2

.subckt A221OD2B A1 A2 B1 B2 C1 VGND VNB VPB VPWR X
X0 a_193_297# A1 VPWR VPB abpmos
X1 a_193_297# A1 VPWR VPB abpmos
X2 a_193_297# A1 VPWR VPB abpmos
X3 a_193_297# A2 VPWR VPB abpmos
X4 a_193_297# A2 VPWR VPB abpmos
X5 a_193_297# A2 VPWR VPB abpmos
X6 X a_27_47# VGND VNB abnmos
X7 X a_27_47# VGND VNB abnmos
X8 X a_27_47# VGND VNB abnmos
X9 X a_27_47# VGND VNB abnmos
X10 a_205_47# B1 a_27_47# VNB abnmos
X11 a_205_47# B1 a_27_47# VNB abnmos
X12 a_465_47# A2 VGND VNB abnmos
X13 a_465_47# A2 VGND VNB abnmos
X14 a_27_47# A1 a_465_47# VNB abnmos
X15 a_27_47# A1 a_465_47# VNB abnmos
X16 a_193_297# B1 a_109_297# VPB abpmos
X17 a_193_297# B1 a_109_297# VPB abpmos
X18 a_193_297# B1 a_109_297# VPB abpmos
X19 a_27_47# C1 VGND VNB abnmos
X20 a_27_47# C1 VGND VNB abnmos
X21 a_27_47# C1 a_109_297# VPB abpmos
X22 a_27_47# C1 a_109_297# VPB abpmos
X23 a_27_47# C1 a_109_297# VPB abpmos
X24 X a_27_47# VPWR VPB abpmos
X25 X a_27_47# VPWR VPB abpmos
X26 X a_27_47# VPWR VPB abpmos
X27 a_109_297# B2 a_193_297# VPB abpmos
X28 a_109_297# B2 a_193_297# VPB abpmos
X29 a_109_297# B2 a_193_297# VPB abpmos
X30 a_205_47# B2 VGND VNB abnmos
X31 a_205_47# B2 VGND VNB abnmos
X32 X a_27_47# VPWR VPB abpmos
X33 X a_27_47# VPWR VPB abpmos
X34 X a_27_47# VPWR VPB abpmos
.ends A221OD2B
