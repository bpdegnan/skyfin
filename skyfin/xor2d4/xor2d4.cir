* XOR2D4 : abstract conversion of sky130_fd_sc_hd__xor2_4
* 100 abstract devices (width -> parallel min-width fingers)
.subckt XOR2D4 A B VGND VPWR X
XXOR2D4B A B VGND VGND VPWR VPWR X XOR2D4B
.ends XOR2D4

.subckt XOR2D4B A B VGND VNB VPB VPWR X
X0 a_806_297# a_112_47# X VPB abpmos
X1 a_806_297# a_112_47# X VPB abpmos
X2 a_806_297# a_112_47# X VPB abpmos
X3 a_27_297# A VPWR VPB abpmos
X4 a_27_297# A VPWR VPB abpmos
X5 a_27_297# A VPWR VPB abpmos
X6 a_806_47# A VGND VNB abnmos
X7 a_806_47# A VGND VNB abnmos
X8 a_27_297# A VPWR VPB abpmos
X9 a_27_297# A VPWR VPB abpmos
X10 a_27_297# A VPWR VPB abpmos
X11 X a_112_47# VGND VNB abnmos
X12 X a_112_47# VGND VNB abnmos
X13 a_806_297# B VPWR VPB abpmos
X14 a_806_297# B VPWR VPB abpmos
X15 a_806_297# B VPWR VPB abpmos
X16 a_806_297# A VPWR VPB abpmos
X17 a_806_297# A VPWR VPB abpmos
X18 a_806_297# A VPWR VPB abpmos
X19 a_112_47# B a_27_297# VPB abpmos
X20 a_112_47# B a_27_297# VPB abpmos
X21 a_112_47# B a_27_297# VPB abpmos
X22 a_112_47# B VGND VNB abnmos
X23 a_112_47# B VGND VNB abnmos
X24 a_806_47# B X VNB abnmos
X25 a_806_47# B X VNB abnmos
X26 a_806_297# A VPWR VPB abpmos
X27 a_806_297# A VPWR VPB abpmos
X28 a_806_297# A VPWR VPB abpmos
X29 a_806_47# A VGND VNB abnmos
X30 a_806_47# A VGND VNB abnmos
X31 a_27_297# A VPWR VPB abpmos
X32 a_27_297# A VPWR VPB abpmos
X33 a_27_297# A VPWR VPB abpmos
X34 a_112_47# B VGND VNB abnmos
X35 a_112_47# B VGND VNB abnmos
X36 a_806_297# A VPWR VPB abpmos
X37 a_806_297# A VPWR VPB abpmos
X38 a_806_297# A VPWR VPB abpmos
X39 a_806_297# a_112_47# X VPB abpmos
X40 a_806_297# a_112_47# X VPB abpmos
X41 a_806_297# a_112_47# X VPB abpmos
X42 a_806_47# B X VNB abnmos
X43 a_806_47# B X VNB abnmos
X44 a_806_297# A VPWR VPB abpmos
X45 a_806_297# A VPWR VPB abpmos
X46 a_806_297# A VPWR VPB abpmos
X47 a_27_297# A VPWR VPB abpmos
X48 a_27_297# A VPWR VPB abpmos
X49 a_27_297# A VPWR VPB abpmos
X50 a_112_47# A VGND VNB abnmos
X51 a_112_47# A VGND VNB abnmos
X52 a_112_47# A VGND VNB abnmos
X53 a_112_47# A VGND VNB abnmos
X54 a_27_297# B a_112_47# VPB abpmos
X55 a_27_297# B a_112_47# VPB abpmos
X56 a_27_297# B a_112_47# VPB abpmos
X57 a_806_47# A VGND VNB abnmos
X58 a_806_47# A VGND VNB abnmos
X59 X a_112_47# VGND VNB abnmos
X60 X a_112_47# VGND VNB abnmos
X61 a_112_47# B a_27_297# VPB abpmos
X62 a_112_47# B a_27_297# VPB abpmos
X63 a_112_47# B a_27_297# VPB abpmos
X64 a_112_47# A VGND VNB abnmos
X65 a_112_47# A VGND VNB abnmos
X66 a_806_47# A VGND VNB abnmos
X67 a_806_47# A VGND VNB abnmos
X68 a_806_297# B VPWR VPB abpmos
X69 a_806_297# B VPWR VPB abpmos
X70 a_806_297# B VPWR VPB abpmos
X71 X a_112_47# VGND VNB abnmos
X72 X a_112_47# VGND VNB abnmos
X73 X B a_806_47# VNB abnmos
X74 X B a_806_47# VNB abnmos
X75 a_112_47# B VGND VNB abnmos
X76 a_112_47# B VGND VNB abnmos
X77 X a_112_47# a_806_297# VPB abpmos
X78 X a_112_47# a_806_297# VPB abpmos
X79 X a_112_47# a_806_297# VPB abpmos
X80 a_112_47# A VGND VNB abnmos
X81 a_112_47# A VGND VNB abnmos
X82 a_112_47# B VGND VNB abnmos
X83 a_112_47# B VGND VNB abnmos
X84 a_806_297# B VPWR VPB abpmos
X85 a_806_297# B VPWR VPB abpmos
X86 a_806_297# B VPWR VPB abpmos
X87 X B a_806_47# VNB abnmos
X88 X B a_806_47# VNB abnmos
X89 X a_112_47# a_806_297# VPB abpmos
X90 X a_112_47# a_806_297# VPB abpmos
X91 X a_112_47# a_806_297# VPB abpmos
X92 X a_112_47# VGND VNB abnmos
X93 X a_112_47# VGND VNB abnmos
X94 a_27_297# B a_112_47# VPB abpmos
X95 a_27_297# B a_112_47# VPB abpmos
X96 a_27_297# B a_112_47# VPB abpmos
X97 a_806_297# B VPWR VPB abpmos
X98 a_806_297# B VPWR VPB abpmos
X99 a_806_297# B VPWR VPB abpmos
.ends XOR2D4B
