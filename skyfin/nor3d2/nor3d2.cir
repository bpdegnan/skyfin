* NOR3D2 : abstract conversion of sky130_fd_sc_hd__nor3_2
* 30 abstract devices (width -> parallel min-width fingers)
.subckt NOR3D2 A B C VGND VPWR Y
XNOR3D2B A B C VGND VGND VPWR VPWR Y NOR3D2B
.ends NOR3D2

.subckt NOR3D2B A B C VGND VNB VPB VPWR Y
X0 Y B VGND VNB abnmos
X1 Y B VGND VNB abnmos
X2 Y C a_281_297# VPB abpmos
X3 Y C a_281_297# VPB abpmos
X4 Y C a_281_297# VPB abpmos
X5 a_27_297# A VPWR VPB abpmos
X6 a_27_297# A VPWR VPB abpmos
X7 a_27_297# A VPWR VPB abpmos
X8 a_281_297# B a_27_297# VPB abpmos
X9 a_281_297# B a_27_297# VPB abpmos
X10 a_281_297# B a_27_297# VPB abpmos
X11 Y B VGND VNB abnmos
X12 Y B VGND VNB abnmos
X13 a_27_297# B a_281_297# VPB abpmos
X14 a_27_297# B a_281_297# VPB abpmos
X15 a_27_297# B a_281_297# VPB abpmos
X16 a_27_297# A VPWR VPB abpmos
X17 a_27_297# A VPWR VPB abpmos
X18 a_27_297# A VPWR VPB abpmos
X19 Y A VGND VNB abnmos
X20 Y A VGND VNB abnmos
X21 Y A VGND VNB abnmos
X22 Y A VGND VNB abnmos
X23 Y C VGND VNB abnmos
X24 Y C VGND VNB abnmos
X25 a_281_297# C Y VPB abpmos
X26 a_281_297# C Y VPB abpmos
X27 a_281_297# C Y VPB abpmos
X28 Y C VGND VNB abnmos
X29 Y C VGND VNB abnmos
.ends NOR3D2B
