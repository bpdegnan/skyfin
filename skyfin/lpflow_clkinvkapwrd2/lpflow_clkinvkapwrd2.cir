* LPFLOW_CLKINVKAPWRD2 : abstract conversion of sky130_fd_sc_hd__lpflow_clkinvkapwr_2
* 11 abstract devices (width -> parallel min-width fingers) ; secondary power ['KAPWR'] collapsed onto VPWR
.subckt LPFLOW_CLKINVKAPWRD2 A VGND VPWR Y
XLPFLOW_CLKINVKAPWRD2B A VPWR VGND VGND VPWR VPWR Y LPFLOW_CLKINVKAPWRD2B
.ends LPFLOW_CLKINVKAPWRD2

.subckt LPFLOW_CLKINVKAPWRD2B A KAPWR VGND VNB VPB VPWR Y
X0 Y A KAPWR VPB abpmos
X1 Y A KAPWR VPB abpmos
X2 Y A KAPWR VPB abpmos
X3 KAPWR A Y VPB abpmos
X4 KAPWR A Y VPB abpmos
X5 KAPWR A Y VPB abpmos
X6 Y A KAPWR VPB abpmos
X7 Y A KAPWR VPB abpmos
X8 Y A KAPWR VPB abpmos
X9 Y A VGND VNB abnmos
X10 Y A VGND VNB abnmos
.ends LPFLOW_CLKINVKAPWRD2B
