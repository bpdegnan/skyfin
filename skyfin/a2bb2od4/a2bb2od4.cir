* A2BB2OD4 : abstract conversion of sky130_fd_sc_hd__a2bb2o_4
* 70 abstract devices (width -> parallel min-width fingers)
.subckt A2BB2OD4 A1_N A2_N B1 B2 VGND VPWR X
XA2BB2OD4B A1_N A2_N B1 B2 VGND VGND VPWR VPWR X A2BB2OD4B
.ends A2BB2OD4

.subckt A2BB2OD4B A1_N A2_N B1 B2 VGND VNB VPB VPWR X
X0 a_415_21# A2_N VGND VNB abnmos
X1 a_415_21# A2_N VGND VNB abnmos
X2 X a_193_47# VGND VNB abnmos
X3 X a_193_47# VGND VNB abnmos
X4 a_193_47# a_415_21# VGND VNB abnmos
X5 a_193_47# a_415_21# VGND VNB abnmos
X6 X a_193_47# VPWR VPB abpmos
X7 X a_193_47# VPWR VPB abpmos
X8 X a_193_47# VPWR VPB abpmos
X9 X a_193_47# VGND VNB abnmos
X10 X a_193_47# VGND VNB abnmos
X11 a_193_47# a_415_21# a_27_297# VPB abpmos
X12 a_193_47# a_415_21# a_27_297# VPB abpmos
X13 a_193_47# a_415_21# a_27_297# VPB abpmos
X14 a_415_21# A2_N VGND VNB abnmos
X15 a_415_21# A2_N VGND VNB abnmos
X16 a_109_47# B1 VGND VNB abnmos
X17 a_109_47# B1 VGND VNB abnmos
X18 a_193_47# a_415_21# VGND VNB abnmos
X19 a_193_47# a_415_21# VGND VNB abnmos
X20 X a_193_47# VPWR VPB abpmos
X21 X a_193_47# VPWR VPB abpmos
X22 X a_193_47# VPWR VPB abpmos
X23 a_415_21# A1_N VGND VNB abnmos
X24 a_415_21# A1_N VGND VNB abnmos
X25 X a_193_47# VPWR VPB abpmos
X26 X a_193_47# VPWR VPB abpmos
X27 X a_193_47# VPWR VPB abpmos
X28 a_193_47# B2 a_109_47# VNB abnmos
X29 a_193_47# B2 a_109_47# VNB abnmos
X30 a_717_297# A1_N VPWR VPB abpmos
X31 a_717_297# A1_N VPWR VPB abpmos
X32 a_717_297# A1_N VPWR VPB abpmos
X33 a_109_47# B2 a_193_47# VNB abnmos
X34 a_109_47# B2 a_193_47# VNB abnmos
X35 a_27_297# B2 VPWR VPB abpmos
X36 a_27_297# B2 VPWR VPB abpmos
X37 a_27_297# B2 VPWR VPB abpmos
X38 a_717_297# A1_N VPWR VPB abpmos
X39 a_717_297# A1_N VPWR VPB abpmos
X40 a_717_297# A1_N VPWR VPB abpmos
X41 a_109_47# B1 VGND VNB abnmos
X42 a_109_47# B1 VGND VNB abnmos
X43 a_415_21# A2_N a_717_297# VPB abpmos
X44 a_415_21# A2_N a_717_297# VPB abpmos
X45 a_415_21# A2_N a_717_297# VPB abpmos
X46 a_27_297# a_415_21# a_193_47# VPB abpmos
X47 a_27_297# a_415_21# a_193_47# VPB abpmos
X48 a_27_297# a_415_21# a_193_47# VPB abpmos
X49 a_27_297# B1 VPWR VPB abpmos
X50 a_27_297# B1 VPWR VPB abpmos
X51 a_27_297# B1 VPWR VPB abpmos
X52 a_27_297# B2 VPWR VPB abpmos
X53 a_27_297# B2 VPWR VPB abpmos
X54 a_27_297# B2 VPWR VPB abpmos
X55 a_415_21# A1_N VGND VNB abnmos
X56 a_415_21# A1_N VGND VNB abnmos
X57 a_717_297# A2_N a_415_21# VPB abpmos
X58 a_717_297# A2_N a_415_21# VPB abpmos
X59 a_717_297# A2_N a_415_21# VPB abpmos
X60 X a_193_47# VGND VNB abnmos
X61 X a_193_47# VGND VNB abnmos
X62 a_27_297# B1 VPWR VPB abpmos
X63 a_27_297# B1 VPWR VPB abpmos
X64 a_27_297# B1 VPWR VPB abpmos
X65 X a_193_47# VPWR VPB abpmos
X66 X a_193_47# VPWR VPB abpmos
X67 X a_193_47# VPWR VPB abpmos
X68 X a_193_47# VGND VNB abnmos
X69 X a_193_47# VGND VNB abnmos
.ends A2BB2OD4B
