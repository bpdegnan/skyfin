* LPFLOW_ISOBUFSRCKAPWRD16 : abstract conversion of sky130_fd_sc_hd__lpflow_isobufsrckapwr_16
* 125 abstract devices (width -> parallel min-width fingers) ; secondary power ['KAPWR'] collapsed onto VPWR
.subckt LPFLOW_ISOBUFSRCKAPWRD16 A SLEEP VGND VPWR X
XLPFLOW_ISOBUFSRCKAPWRD16B A SLEEP VPWR VGND VGND VPWR VPWR X LPFLOW_ISOBUFSRCKAPWRD16B
.ends LPFLOW_ISOBUFSRCKAPWRD16

.subckt LPFLOW_ISOBUFSRCKAPWRD16B A SLEEP KAPWR VGND VNB VPB VPWR X
X0 X a_1122_47# VGND VNB abnmos
X1 a_255_297# SLEEP VPWR VPB abpmos
X2 a_255_297# SLEEP VPWR VPB abpmos
X3 a_255_297# SLEEP VPWR VPB abpmos
X4 KAPWR a_1122_47# X VPB abpmos
X5 KAPWR a_1122_47# X VPB abpmos
X6 KAPWR a_1122_47# X VPB abpmos
X7 a_1122_47# a_341_47# VGND VNB abnmos
X8 X a_1122_47# VGND VNB abnmos
X9 X a_1122_47# KAPWR VPB abpmos
X10 X a_1122_47# KAPWR VPB abpmos
X11 X a_1122_47# KAPWR VPB abpmos
X12 a_341_47# SLEEP VGND VNB abnmos
X13 a_341_47# SLEEP VGND VNB abnmos
X14 X a_1122_47# VGND VNB abnmos
X15 KAPWR a_341_47# a_1122_47# VPB abpmos
X16 KAPWR a_341_47# a_1122_47# VPB abpmos
X17 KAPWR a_341_47# a_1122_47# VPB abpmos
X18 a_147_47# A VPWR VPB abpmos
X19 a_147_47# A VPWR VPB abpmos
X20 a_147_47# A VPWR VPB abpmos
X21 X a_1122_47# VGND VNB abnmos
X22 a_341_47# SLEEP VGND VNB abnmos
X23 a_341_47# SLEEP VGND VNB abnmos
X24 X a_1122_47# KAPWR VPB abpmos
X25 X a_1122_47# KAPWR VPB abpmos
X26 X a_1122_47# KAPWR VPB abpmos
X27 X a_1122_47# KAPWR VPB abpmos
X28 X a_1122_47# KAPWR VPB abpmos
X29 X a_1122_47# KAPWR VPB abpmos
X30 a_1122_47# a_341_47# VGND VNB abnmos
X31 a_255_297# a_147_47# a_341_47# VPB abpmos
X32 a_255_297# a_147_47# a_341_47# VPB abpmos
X33 a_255_297# a_147_47# a_341_47# VPB abpmos
X34 KAPWR a_1122_47# X VPB abpmos
X35 KAPWR a_1122_47# X VPB abpmos
X36 KAPWR a_1122_47# X VPB abpmos
X37 a_1122_47# a_341_47# VGND VNB abnmos
X38 X a_1122_47# VGND VNB abnmos
X39 a_1122_47# a_341_47# KAPWR VPB abpmos
X40 a_1122_47# a_341_47# KAPWR VPB abpmos
X41 a_1122_47# a_341_47# KAPWR VPB abpmos
X42 a_341_47# a_147_47# VGND VNB abnmos
X43 a_341_47# a_147_47# VGND VNB abnmos
X44 X a_1122_47# VGND VNB abnmos
X45 a_1122_47# a_341_47# VGND VNB abnmos
X46 a_147_47# A VGND VNB abnmos
X47 a_147_47# A VGND VNB abnmos
X48 X a_1122_47# VGND VNB abnmos
X49 X a_1122_47# VGND VNB abnmos
X50 KAPWR a_1122_47# X VPB abpmos
X51 KAPWR a_1122_47# X VPB abpmos
X52 KAPWR a_1122_47# X VPB abpmos
X53 X a_1122_47# KAPWR VPB abpmos
X54 X a_1122_47# KAPWR VPB abpmos
X55 X a_1122_47# KAPWR VPB abpmos
X56 KAPWR a_1122_47# X VPB abpmos
X57 KAPWR a_1122_47# X VPB abpmos
X58 KAPWR a_1122_47# X VPB abpmos
X59 a_341_47# a_147_47# VGND VNB abnmos
X60 a_341_47# a_147_47# VGND VNB abnmos
X61 a_255_297# a_147_47# a_341_47# VPB abpmos
X62 a_255_297# a_147_47# a_341_47# VPB abpmos
X63 a_255_297# a_147_47# a_341_47# VPB abpmos
X64 X a_1122_47# KAPWR VPB abpmos
X65 X a_1122_47# KAPWR VPB abpmos
X66 X a_1122_47# KAPWR VPB abpmos
X67 KAPWR a_1122_47# X VPB abpmos
X68 KAPWR a_1122_47# X VPB abpmos
X69 KAPWR a_1122_47# X VPB abpmos
X70 X a_1122_47# VGND VNB abnmos
X71 a_255_297# SLEEP VPWR VPB abpmos
X72 a_255_297# SLEEP VPWR VPB abpmos
X73 a_255_297# SLEEP VPWR VPB abpmos
X74 X a_1122_47# KAPWR VPB abpmos
X75 X a_1122_47# KAPWR VPB abpmos
X76 X a_1122_47# KAPWR VPB abpmos
X77 a_255_297# SLEEP VPWR VPB abpmos
X78 a_255_297# SLEEP VPWR VPB abpmos
X79 a_255_297# SLEEP VPWR VPB abpmos
X80 X a_1122_47# VGND VNB abnmos
X81 a_341_47# a_147_47# a_255_297# VPB abpmos
X82 a_341_47# a_147_47# a_255_297# VPB abpmos
X83 a_341_47# a_147_47# a_255_297# VPB abpmos
X84 X a_1122_47# VGND VNB abnmos
X85 X a_1122_47# VGND VNB abnmos
X86 a_341_47# a_147_47# a_255_297# VPB abpmos
X87 a_341_47# a_147_47# a_255_297# VPB abpmos
X88 a_341_47# a_147_47# a_255_297# VPB abpmos
X89 a_341_47# a_147_47# VGND VNB abnmos
X90 a_341_47# a_147_47# VGND VNB abnmos
X91 a_341_47# SLEEP VGND VNB abnmos
X92 a_341_47# SLEEP VGND VNB abnmos
X93 X a_1122_47# VGND VNB abnmos
X94 a_255_297# SLEEP VPWR VPB abpmos
X95 a_255_297# SLEEP VPWR VPB abpmos
X96 a_255_297# SLEEP VPWR VPB abpmos
X97 KAPWR a_1122_47# X VPB abpmos
X98 KAPWR a_1122_47# X VPB abpmos
X99 KAPWR a_1122_47# X VPB abpmos
X100 X a_1122_47# KAPWR VPB abpmos
X101 X a_1122_47# KAPWR VPB abpmos
X102 X a_1122_47# KAPWR VPB abpmos
X103 KAPWR a_1122_47# X VPB abpmos
X104 KAPWR a_1122_47# X VPB abpmos
X105 KAPWR a_1122_47# X VPB abpmos
X106 X a_1122_47# VGND VNB abnmos
X107 a_1122_47# a_341_47# KAPWR VPB abpmos
X108 a_1122_47# a_341_47# KAPWR VPB abpmos
X109 a_1122_47# a_341_47# KAPWR VPB abpmos
X110 KAPWR a_1122_47# X VPB abpmos
X111 KAPWR a_1122_47# X VPB abpmos
X112 KAPWR a_1122_47# X VPB abpmos
X113 X a_1122_47# KAPWR VPB abpmos
X114 X a_1122_47# KAPWR VPB abpmos
X115 X a_1122_47# KAPWR VPB abpmos
X116 X a_1122_47# VGND VNB abnmos
X117 KAPWR a_341_47# a_1122_47# VPB abpmos
X118 KAPWR a_341_47# a_1122_47# VPB abpmos
X119 KAPWR a_341_47# a_1122_47# VPB abpmos
X120 a_341_47# a_147_47# VGND VNB abnmos
X121 a_341_47# a_147_47# VGND VNB abnmos
X122 a_341_47# SLEEP VGND VNB abnmos
X123 a_341_47# SLEEP VGND VNB abnmos
X124 X a_1122_47# VGND VNB abnmos
.ends LPFLOW_ISOBUFSRCKAPWRD16B
