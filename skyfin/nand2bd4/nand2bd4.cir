* NAND2BD4 : abstract conversion of sky130_fd_sc_hd__nand2b_4
* 45 abstract devices (width -> parallel min-width fingers)
.subckt NAND2BD4 A_N B VGND VPWR Y
XNAND2BD4B A_N B VGND VGND VPWR VPWR Y NAND2BD4B
.ends NAND2BD4

.subckt NAND2BD4B A_N B VGND VNB VPB VPWR Y
X0 Y B VPWR VPB abpmos
X1 Y B VPWR VPB abpmos
X2 Y B VPWR VPB abpmos
X3 a_215_47# B VGND VNB abnmos
X4 a_215_47# B VGND VNB abnmos
X5 Y B VPWR VPB abpmos
X6 Y B VPWR VPB abpmos
X7 Y B VPWR VPB abpmos
X8 a_215_47# a_27_47# Y VNB abnmos
X9 a_215_47# a_27_47# Y VNB abnmos
X10 Y a_27_47# VPWR VPB abpmos
X11 Y a_27_47# VPWR VPB abpmos
X12 Y a_27_47# VPWR VPB abpmos
X13 a_215_47# B VGND VNB abnmos
X14 a_215_47# B VGND VNB abnmos
X15 Y a_27_47# VPWR VPB abpmos
X16 Y a_27_47# VPWR VPB abpmos
X17 Y a_27_47# VPWR VPB abpmos
X18 a_215_47# B VGND VNB abnmos
X19 a_215_47# B VGND VNB abnmos
X20 Y a_27_47# VPWR VPB abpmos
X21 Y a_27_47# VPWR VPB abpmos
X22 Y a_27_47# VPWR VPB abpmos
X23 a_215_47# B VGND VNB abnmos
X24 a_215_47# B VGND VNB abnmos
X25 Y a_27_47# VPWR VPB abpmos
X26 Y a_27_47# VPWR VPB abpmos
X27 Y a_27_47# VPWR VPB abpmos
X28 Y B VPWR VPB abpmos
X29 Y B VPWR VPB abpmos
X30 Y B VPWR VPB abpmos
X31 Y a_27_47# a_215_47# VNB abnmos
X32 Y a_27_47# a_215_47# VNB abnmos
X33 a_215_47# a_27_47# Y VNB abnmos
X34 a_215_47# a_27_47# Y VNB abnmos
X35 a_27_47# A_N VGND VNB abnmos
X36 a_27_47# A_N VGND VNB abnmos
X37 a_27_47# A_N VPWR VPB abpmos
X38 a_27_47# A_N VPWR VPB abpmos
X39 a_27_47# A_N VPWR VPB abpmos
X40 Y a_27_47# a_215_47# VNB abnmos
X41 Y a_27_47# a_215_47# VNB abnmos
X42 Y B VPWR VPB abpmos
X43 Y B VPWR VPB abpmos
X44 Y B VPWR VPB abpmos
.ends NAND2BD4B
