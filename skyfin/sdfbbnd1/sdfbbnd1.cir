* SDFBBND1 : abstract conversion of sky130_fd_sc_hd__sdfbbn_1
* 70 abstract devices (width -> parallel min-width fingers)
.subckt SDFBBND1 CLK_N D RESET_B SCD SCE SET_B VGND VPWR Q Q_N
XSDFBBND1B CLK_N D RESET_B SCD SCE SET_B VGND VGND VPWR VPWR Q Q_N SDFBBND1B
.ends SDFBBND1

.subckt SDFBBND1B CLK_N D RESET_B SCD SCE SET_B VGND VNB VPB VPWR Q Q_N
X0 a_1102_21# SET_B VPWR VPB abpmos
X1 a_1800_413# a_1887_21# VPWR VPB abpmos
X2 a_1614_47# a_1102_21# VGND VNB abnmos
X3 a_1614_47# a_1102_21# VGND VNB abnmos
X4 a_2596_47# a_1887_21# VPWR VPB abpmos
X5 a_2596_47# a_1887_21# VPWR VPB abpmos
X6 a_1351_329# a_1396_21# VPWR VPB abpmos
X7 a_1351_329# a_1396_21# VPWR VPB abpmos
X8 a_1887_21# a_1714_47# a_2122_329# VPB abpmos
X9 a_1887_21# a_1714_47# a_2122_329# VPB abpmos
X10 a_2122_329# a_1396_21# VPWR VPB abpmos
X11 a_2122_329# a_1396_21# VPWR VPB abpmos
X12 Q_N a_1887_21# VGND VNB abnmos
X13 Q_N a_1887_21# VGND VNB abnmos
X14 a_1822_47# a_1887_21# VGND VNB abnmos
X15 a_917_47# a_193_47# a_1017_413# VPB abpmos
X16 a_1017_413# a_1102_21# VPWR VPB abpmos
X17 a_1241_47# SET_B VGND VNB abnmos
X18 a_1102_21# a_917_47# a_1351_329# VPB abpmos
X19 a_1102_21# a_917_47# a_1351_329# VPB abpmos
X20 a_735_47# a_423_315# VGND VNB abnmos
X21 a_1572_329# a_1102_21# VPWR VPB abpmos
X22 a_1572_329# a_1102_21# VPWR VPB abpmos
X23 a_917_47# a_27_47# a_1030_47# VNB abnmos
X24 a_381_363# SCD VPWR VPB abpmos
X25 a_381_363# SCD VPWR VPB abpmos
X26 a_381_363# a_423_315# a_453_47# VPB abpmos
X27 a_381_363# a_423_315# a_453_47# VPB abpmos
X28 a_1030_47# a_1102_21# VGND VNB abnmos
X29 a_1887_21# a_1396_21# a_2004_47# VNB abnmos
X30 a_1887_21# a_1396_21# a_2004_47# VNB abnmos
X31 a_381_47# SCE a_453_47# VNB abnmos
X32 a_735_47# D a_453_47# VNB abnmos
X33 a_1572_329# a_193_47# a_1714_47# VPB abpmos
X34 Q_N a_1887_21# VPWR VPB abpmos
X35 Q_N a_1887_21# VPWR VPB abpmos
X36 Q_N a_1887_21# VPWR VPB abpmos
X37 a_2596_47# a_1887_21# VGND VNB abnmos
X38 a_423_315# SCE VGND VNB abnmos
X39 a_2004_47# a_1714_47# a_1887_21# VNB abnmos
X40 a_2004_47# a_1714_47# a_1887_21# VNB abnmos
X41 a_1396_21# RESET_B VGND VNB abnmos
X42 a_1241_47# a_917_47# a_1102_21# VNB abnmos
X43 a_1241_47# a_917_47# a_1102_21# VNB abnmos
X44 a_1714_47# a_27_47# a_1800_413# VPB abpmos
X45 Q a_2596_47# VGND VNB abnmos
X46 Q a_2596_47# VGND VNB abnmos
X47 a_1396_21# RESET_B VPWR VPB abpmos
X48 a_1396_21# RESET_B VPWR VPB abpmos
X49 a_423_315# SCE VPWR VPB abpmos
X50 a_193_47# a_27_47# VGND VNB abnmos
X51 a_1614_47# a_27_47# a_1714_47# VNB abnmos
X52 a_27_47# CLK_N VGND VNB abnmos
X53 a_27_47# CLK_N VPWR VPB abpmos
X54 a_27_47# CLK_N VPWR VPB abpmos
X55 a_752_413# D a_453_47# VPB abpmos
X56 a_1714_47# a_193_47# a_1822_47# VNB abnmos
X57 Q a_2596_47# VPWR VPB abpmos
X58 Q a_2596_47# VPWR VPB abpmos
X59 Q a_2596_47# VPWR VPB abpmos
X60 a_193_47# a_27_47# VPWR VPB abpmos
X61 a_193_47# a_27_47# VPWR VPB abpmos
X62 a_453_47# a_27_47# a_917_47# VPB abpmos
X63 a_381_47# SCD VGND VNB abnmos
X64 a_453_47# a_193_47# a_917_47# VNB abnmos
X65 a_752_413# SCE VPWR VPB abpmos
X66 a_1887_21# SET_B VPWR VPB abpmos
X67 a_1102_21# a_1396_21# a_1241_47# VNB abnmos
X68 a_1102_21# a_1396_21# a_1241_47# VNB abnmos
X69 a_2004_47# SET_B VGND VNB abnmos
.ends SDFBBND1B
