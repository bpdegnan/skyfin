* O2111AD1 : abstract conversion of sky130_fd_sc_hd__o2111a_1
* 30 abstract devices (width -> parallel min-width fingers)
.subckt O2111AD1 A1 A2 B1 C1 D1 VGND VPWR X
XO2111AD1B A1 A2 B1 C1 D1 VGND VGND VPWR VPWR X O2111AD1B
.ends O2111AD1

.subckt O2111AD1B A1 A2 B1 C1 D1 VGND VNB VPB VPWR X
X0 a_79_21# D1 VPWR VPB abpmos
X1 a_79_21# D1 VPWR VPB abpmos
X2 a_79_21# D1 VPWR VPB abpmos
X3 a_306_47# C1 a_409_47# VNB abnmos
X4 a_306_47# C1 a_409_47# VNB abnmos
X5 a_512_47# A1 VGND VNB abnmos
X6 a_512_47# A1 VGND VNB abnmos
X7 a_79_21# D1 a_306_47# VNB abnmos
X8 a_79_21# D1 a_306_47# VNB abnmos
X9 a_512_47# A2 VGND VNB abnmos
X10 a_512_47# A2 VGND VNB abnmos
X11 a_79_21# B1 VPWR VPB abpmos
X12 a_79_21# B1 VPWR VPB abpmos
X13 a_79_21# B1 VPWR VPB abpmos
X14 a_79_21# C1 VPWR VPB abpmos
X15 a_79_21# C1 VPWR VPB abpmos
X16 a_79_21# C1 VPWR VPB abpmos
X17 a_79_21# A2 a_676_297# VPB abpmos
X18 a_79_21# A2 a_676_297# VPB abpmos
X19 a_79_21# A2 a_676_297# VPB abpmos
X20 a_676_297# A1 VPWR VPB abpmos
X21 a_676_297# A1 VPWR VPB abpmos
X22 a_676_297# A1 VPWR VPB abpmos
X23 a_409_47# B1 a_512_47# VNB abnmos
X24 a_409_47# B1 a_512_47# VNB abnmos
X25 X a_79_21# VGND VNB abnmos
X26 X a_79_21# VGND VNB abnmos
X27 X a_79_21# VPWR VPB abpmos
X28 X a_79_21# VPWR VPB abpmos
X29 X a_79_21# VPWR VPB abpmos
.ends O2111AD1B
