* OR4D2 : abstract conversion of sky130_fd_sc_hd__or4_2
* 18 abstract devices (width -> parallel min-width fingers)
.subckt OR4D2 A B C D VGND VPWR X
XOR4D2B A B C D VGND VGND VPWR VPWR X OR4D2B
.ends OR4D2

.subckt OR4D2B A B C D VGND VNB VPB VPWR X
X0 a_27_297# A VGND VNB abnmos
X1 a_27_297# D VGND VNB abnmos
X2 X a_27_297# VGND VNB abnmos
X3 X a_27_297# VGND VNB abnmos
X4 a_27_297# B VGND VNB abnmos
X5 X a_27_297# VGND VNB abnmos
X6 X a_27_297# VGND VNB abnmos
X7 a_109_297# C a_205_297# VPB abpmos
X8 a_205_297# B a_277_297# VPB abpmos
X9 a_27_297# C VGND VNB abnmos
X10 a_277_297# A VPWR VPB abpmos
X11 X a_27_297# VPWR VPB abpmos
X12 X a_27_297# VPWR VPB abpmos
X13 X a_27_297# VPWR VPB abpmos
X14 a_27_297# D a_109_297# VPB abpmos
X15 X a_27_297# VPWR VPB abpmos
X16 X a_27_297# VPWR VPB abpmos
X17 X a_27_297# VPWR VPB abpmos
.ends OR4D2B
