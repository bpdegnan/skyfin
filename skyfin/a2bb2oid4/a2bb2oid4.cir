* A2BB2OID4 : abstract conversion of sky130_fd_sc_hd__a2bb2oi_4
* 100 abstract devices (width -> parallel min-width fingers)
.subckt A2BB2OID4 A1_N A2_N B1 B2 VGND VPWR Y
XA2BB2OID4B A1_N A2_N B1 B2 VGND VGND VPWR VPWR Y A2BB2OID4B
.ends A2BB2OID4

.subckt A2BB2OID4B A1_N A2_N B1 B2 VGND VNB VPB VPWR Y
X0 Y a_751_21# a_27_297# VPB abpmos
X1 Y a_751_21# a_27_297# VPB abpmos
X2 Y a_751_21# a_27_297# VPB abpmos
X3 a_1139_297# A1_N VPWR VPB abpmos
X4 a_1139_297# A1_N VPWR VPB abpmos
X5 a_1139_297# A1_N VPWR VPB abpmos
X6 a_751_21# A2_N a_1139_297# VPB abpmos
X7 a_751_21# A2_N a_1139_297# VPB abpmos
X8 a_751_21# A2_N a_1139_297# VPB abpmos
X9 Y B2 a_109_47# VNB abnmos
X10 Y B2 a_109_47# VNB abnmos
X11 a_751_21# A1_N VGND VNB abnmos
X12 a_751_21# A1_N VGND VNB abnmos
X13 Y B2 a_109_47# VNB abnmos
X14 Y B2 a_109_47# VNB abnmos
X15 a_1139_297# A1_N VPWR VPB abpmos
X16 a_1139_297# A1_N VPWR VPB abpmos
X17 a_1139_297# A1_N VPWR VPB abpmos
X18 a_751_21# A2_N VGND VNB abnmos
X19 a_751_21# A2_N VGND VNB abnmos
X20 a_27_297# a_751_21# Y VPB abpmos
X21 a_27_297# a_751_21# Y VPB abpmos
X22 a_27_297# a_751_21# Y VPB abpmos
X23 a_27_297# B2 VPWR VPB abpmos
X24 a_27_297# B2 VPWR VPB abpmos
X25 a_27_297# B2 VPWR VPB abpmos
X26 a_27_297# B1 VPWR VPB abpmos
X27 a_27_297# B1 VPWR VPB abpmos
X28 a_27_297# B1 VPWR VPB abpmos
X29 a_109_47# B2 Y VNB abnmos
X30 a_109_47# B2 Y VNB abnmos
X31 a_751_21# A2_N VGND VNB abnmos
X32 a_751_21# A2_N VGND VNB abnmos
X33 Y a_751_21# a_27_297# VPB abpmos
X34 Y a_751_21# a_27_297# VPB abpmos
X35 Y a_751_21# a_27_297# VPB abpmos
X36 Y a_751_21# VGND VNB abnmos
X37 Y a_751_21# VGND VNB abnmos
X38 a_751_21# A2_N a_1139_297# VPB abpmos
X39 a_751_21# A2_N a_1139_297# VPB abpmos
X40 a_751_21# A2_N a_1139_297# VPB abpmos
X41 a_751_21# A2_N VGND VNB abnmos
X42 a_751_21# A2_N VGND VNB abnmos
X43 a_27_297# B2 VPWR VPB abpmos
X44 a_27_297# B2 VPWR VPB abpmos
X45 a_27_297# B2 VPWR VPB abpmos
X46 a_27_297# a_751_21# Y VPB abpmos
X47 a_27_297# a_751_21# Y VPB abpmos
X48 a_27_297# a_751_21# Y VPB abpmos
X49 a_109_47# B2 Y VNB abnmos
X50 a_109_47# B2 Y VNB abnmos
X51 a_1139_297# A2_N a_751_21# VPB abpmos
X52 a_1139_297# A2_N a_751_21# VPB abpmos
X53 a_1139_297# A2_N a_751_21# VPB abpmos
X54 Y a_751_21# VGND VNB abnmos
X55 Y a_751_21# VGND VNB abnmos
X56 a_751_21# A1_N VGND VNB abnmos
X57 a_751_21# A1_N VGND VNB abnmos
X58 Y a_751_21# VGND VNB abnmos
X59 Y a_751_21# VGND VNB abnmos
X60 Y a_751_21# VGND VNB abnmos
X61 Y a_751_21# VGND VNB abnmos
X62 a_109_47# B1 VGND VNB abnmos
X63 a_109_47# B1 VGND VNB abnmos
X64 a_109_47# B1 VGND VNB abnmos
X65 a_109_47# B1 VGND VNB abnmos
X66 a_27_297# B1 VPWR VPB abpmos
X67 a_27_297# B1 VPWR VPB abpmos
X68 a_27_297# B1 VPWR VPB abpmos
X69 a_109_47# B1 VGND VNB abnmos
X70 a_109_47# B1 VGND VNB abnmos
X71 a_751_21# A1_N VGND VNB abnmos
X72 a_751_21# A1_N VGND VNB abnmos
X73 a_27_297# B2 VPWR VPB abpmos
X74 a_27_297# B2 VPWR VPB abpmos
X75 a_27_297# B2 VPWR VPB abpmos
X76 a_27_297# B1 VPWR VPB abpmos
X77 a_27_297# B1 VPWR VPB abpmos
X78 a_27_297# B1 VPWR VPB abpmos
X79 a_1139_297# A1_N VPWR VPB abpmos
X80 a_1139_297# A1_N VPWR VPB abpmos
X81 a_1139_297# A1_N VPWR VPB abpmos
X82 a_27_297# B1 VPWR VPB abpmos
X83 a_27_297# B1 VPWR VPB abpmos
X84 a_27_297# B1 VPWR VPB abpmos
X85 a_1139_297# A2_N a_751_21# VPB abpmos
X86 a_1139_297# A2_N a_751_21# VPB abpmos
X87 a_1139_297# A2_N a_751_21# VPB abpmos
X88 a_109_47# B1 VGND VNB abnmos
X89 a_109_47# B1 VGND VNB abnmos
X90 a_751_21# A1_N VGND VNB abnmos
X91 a_751_21# A1_N VGND VNB abnmos
X92 a_751_21# A2_N VGND VNB abnmos
X93 a_751_21# A2_N VGND VNB abnmos
X94 a_27_297# B2 VPWR VPB abpmos
X95 a_27_297# B2 VPWR VPB abpmos
X96 a_27_297# B2 VPWR VPB abpmos
X97 a_1139_297# A1_N VPWR VPB abpmos
X98 a_1139_297# A1_N VPWR VPB abpmos
X99 a_1139_297# A1_N VPWR VPB abpmos
.ends A2BB2OID4B
