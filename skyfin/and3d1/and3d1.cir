* AND3D1 : abstract conversion of sky130_fd_sc_hd__and3_1
* 11 abstract devices (width -> parallel min-width fingers)
.subckt AND3D1 A B C VGND VPWR X
XAND3D1B A B C VGND VGND VPWR VPWR X AND3D1B
.ends AND3D1

.subckt AND3D1B A B C VGND VNB VPB VPWR X
X0 a_181_47# C VGND VNB abnmos
X1 a_27_47# A VPWR VPB abpmos
X2 a_27_47# B VPWR VPB abpmos
X3 X a_27_47# VPWR VPB abpmos
X4 X a_27_47# VPWR VPB abpmos
X5 X a_27_47# VPWR VPB abpmos
X6 a_109_47# B a_181_47# VNB abnmos
X7 a_27_47# A a_109_47# VNB abnmos
X8 X a_27_47# VGND VNB abnmos
X9 X a_27_47# VGND VNB abnmos
X10 a_27_47# C VPWR VPB abpmos
.ends AND3D1B
