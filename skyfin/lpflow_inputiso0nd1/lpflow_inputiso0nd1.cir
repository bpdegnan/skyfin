* LPFLOW_INPUTISO0ND1 : abstract conversion of sky130_fd_sc_hd__lpflow_inputiso0n_1
* 9 abstract devices (width -> parallel min-width fingers)
.subckt LPFLOW_INPUTISO0ND1 A SLEEP_B VGND VPWR X
XLPFLOW_INPUTISO0ND1B A SLEEP_B VGND VGND VPWR VPWR X LPFLOW_INPUTISO0ND1B
.ends LPFLOW_INPUTISO0ND1

.subckt LPFLOW_INPUTISO0ND1B A SLEEP_B VGND VNB VPB VPWR X
X0 X a_59_75# VGND VNB abnmos
X1 X a_59_75# VGND VNB abnmos
X2 a_59_75# A VPWR VPB abpmos
X3 a_59_75# A a_145_75# VNB abnmos
X4 a_59_75# SLEEP_B VPWR VPB abpmos
X5 a_145_75# SLEEP_B VGND VNB abnmos
X6 X a_59_75# VPWR VPB abpmos
X7 X a_59_75# VPWR VPB abpmos
X8 X a_59_75# VPWR VPB abpmos
.ends LPFLOW_INPUTISO0ND1B
