* LPFLOW_CLKINVKAPWRD16 : abstract conversion of sky130_fd_sc_hd__lpflow_clkinvkapwr_16
* 88 abstract devices (width -> parallel min-width fingers) ; secondary power ['KAPWR'] collapsed onto VPWR
.subckt LPFLOW_CLKINVKAPWRD16 A VGND VPWR Y
XLPFLOW_CLKINVKAPWRD16B A VPWR VGND VGND VPWR VPWR Y LPFLOW_CLKINVKAPWRD16B
.ends LPFLOW_CLKINVKAPWRD16

.subckt LPFLOW_CLKINVKAPWRD16B A KAPWR VGND VNB VPB VPWR Y
X0 Y A KAPWR VPB abpmos
X1 Y A KAPWR VPB abpmos
X2 Y A KAPWR VPB abpmos
X3 KAPWR A Y VPB abpmos
X4 KAPWR A Y VPB abpmos
X5 KAPWR A Y VPB abpmos
X6 KAPWR A Y VPB abpmos
X7 KAPWR A Y VPB abpmos
X8 KAPWR A Y VPB abpmos
X9 Y A KAPWR VPB abpmos
X10 Y A KAPWR VPB abpmos
X11 Y A KAPWR VPB abpmos
X12 Y A KAPWR VPB abpmos
X13 Y A KAPWR VPB abpmos
X14 Y A KAPWR VPB abpmos
X15 KAPWR A Y VPB abpmos
X16 KAPWR A Y VPB abpmos
X17 KAPWR A Y VPB abpmos
X18 KAPWR A Y VPB abpmos
X19 KAPWR A Y VPB abpmos
X20 KAPWR A Y VPB abpmos
X21 KAPWR A Y VPB abpmos
X22 KAPWR A Y VPB abpmos
X23 KAPWR A Y VPB abpmos
X24 Y A KAPWR VPB abpmos
X25 Y A KAPWR VPB abpmos
X26 Y A KAPWR VPB abpmos
X27 KAPWR A Y VPB abpmos
X28 KAPWR A Y VPB abpmos
X29 KAPWR A Y VPB abpmos
X30 Y A VGND VNB abnmos
X31 KAPWR A Y VPB abpmos
X32 KAPWR A Y VPB abpmos
X33 KAPWR A Y VPB abpmos
X34 Y A VGND VNB abnmos
X35 KAPWR A Y VPB abpmos
X36 KAPWR A Y VPB abpmos
X37 KAPWR A Y VPB abpmos
X38 Y A VGND VNB abnmos
X39 Y A VGND VNB abnmos
X40 Y A KAPWR VPB abpmos
X41 Y A KAPWR VPB abpmos
X42 Y A KAPWR VPB abpmos
X43 Y A VGND VNB abnmos
X44 Y A KAPWR VPB abpmos
X45 Y A KAPWR VPB abpmos
X46 Y A KAPWR VPB abpmos
X47 Y A VGND VNB abnmos
X48 Y A VGND VNB abnmos
X49 KAPWR A Y VPB abpmos
X50 KAPWR A Y VPB abpmos
X51 KAPWR A Y VPB abpmos
X52 Y A KAPWR VPB abpmos
X53 Y A KAPWR VPB abpmos
X54 Y A KAPWR VPB abpmos
X55 Y A VGND VNB abnmos
X56 Y A VGND VNB abnmos
X57 Y A KAPWR VPB abpmos
X58 Y A KAPWR VPB abpmos
X59 Y A KAPWR VPB abpmos
X60 Y A VGND VNB abnmos
X61 Y A KAPWR VPB abpmos
X62 Y A KAPWR VPB abpmos
X63 Y A KAPWR VPB abpmos
X64 Y A VGND VNB abnmos
X65 KAPWR A Y VPB abpmos
X66 KAPWR A Y VPB abpmos
X67 KAPWR A Y VPB abpmos
X68 Y A KAPWR VPB abpmos
X69 Y A KAPWR VPB abpmos
X70 Y A KAPWR VPB abpmos
X71 Y A VGND VNB abnmos
X72 KAPWR A Y VPB abpmos
X73 KAPWR A Y VPB abpmos
X74 KAPWR A Y VPB abpmos
X75 Y A VGND VNB abnmos
X76 Y A KAPWR VPB abpmos
X77 Y A KAPWR VPB abpmos
X78 Y A KAPWR VPB abpmos
X79 Y A VGND VNB abnmos
X80 Y A KAPWR VPB abpmos
X81 Y A KAPWR VPB abpmos
X82 Y A KAPWR VPB abpmos
X83 KAPWR A Y VPB abpmos
X84 KAPWR A Y VPB abpmos
X85 KAPWR A Y VPB abpmos
X86 Y A VGND VNB abnmos
X87 Y A VGND VNB abnmos
.ends LPFLOW_CLKINVKAPWRD16B
