* A2BB2OID2 : abstract conversion of sky130_fd_sc_hd__a2bb2oi_2
* 50 abstract devices (width -> parallel min-width fingers)
.subckt A2BB2OID2 A1_N A2_N B1 B2 VGND VPWR Y
XA2BB2OID2B A1_N A2_N B1 B2 VGND VGND VPWR VPWR Y A2BB2OID2B
.ends A2BB2OID2

.subckt A2BB2OID2B A1_N A2_N B1 B2 VGND VNB VPB VPWR Y
X0 a_136_47# B2 Y VNB abnmos
X1 a_136_47# B2 Y VNB abnmos
X2 a_54_297# B2 VPWR VPB abpmos
X3 a_54_297# B2 VPWR VPB abpmos
X4 a_54_297# B2 VPWR VPB abpmos
X5 a_442_21# A2_N VGND VNB abnmos
X6 a_442_21# A2_N VGND VNB abnmos
X7 Y a_442_21# VGND VNB abnmos
X8 Y a_442_21# VGND VNB abnmos
X9 a_442_21# A2_N VGND VNB abnmos
X10 a_442_21# A2_N VGND VNB abnmos
X11 a_442_21# A1_N VGND VNB abnmos
X12 a_442_21# A1_N VGND VNB abnmos
X13 a_54_297# B1 VPWR VPB abpmos
X14 a_54_297# B1 VPWR VPB abpmos
X15 a_54_297# B1 VPWR VPB abpmos
X16 Y a_442_21# VGND VNB abnmos
X17 Y a_442_21# VGND VNB abnmos
X18 a_662_297# A1_N VPWR VPB abpmos
X19 a_662_297# A1_N VPWR VPB abpmos
X20 a_662_297# A1_N VPWR VPB abpmos
X21 a_442_21# A1_N VGND VNB abnmos
X22 a_442_21# A1_N VGND VNB abnmos
X23 a_136_47# B1 VGND VNB abnmos
X24 a_136_47# B1 VGND VNB abnmos
X25 a_54_297# B1 VPWR VPB abpmos
X26 a_54_297# B1 VPWR VPB abpmos
X27 a_54_297# B1 VPWR VPB abpmos
X28 a_662_297# A1_N VPWR VPB abpmos
X29 a_662_297# A1_N VPWR VPB abpmos
X30 a_662_297# A1_N VPWR VPB abpmos
X31 Y a_442_21# a_54_297# VPB abpmos
X32 Y a_442_21# a_54_297# VPB abpmos
X33 Y a_442_21# a_54_297# VPB abpmos
X34 a_442_21# A2_N a_662_297# VPB abpmos
X35 a_442_21# A2_N a_662_297# VPB abpmos
X36 a_442_21# A2_N a_662_297# VPB abpmos
X37 Y B2 a_136_47# VNB abnmos
X38 Y B2 a_136_47# VNB abnmos
X39 a_54_297# B2 VPWR VPB abpmos
X40 a_54_297# B2 VPWR VPB abpmos
X41 a_54_297# B2 VPWR VPB abpmos
X42 a_136_47# B1 VGND VNB abnmos
X43 a_136_47# B1 VGND VNB abnmos
X44 a_54_297# a_442_21# Y VPB abpmos
X45 a_54_297# a_442_21# Y VPB abpmos
X46 a_54_297# a_442_21# Y VPB abpmos
X47 a_662_297# A2_N a_442_21# VPB abpmos
X48 a_662_297# A2_N a_442_21# VPB abpmos
X49 a_662_297# A2_N a_442_21# VPB abpmos
.ends A2BB2OID2B
