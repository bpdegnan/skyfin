* DECAPD12 : abstract conversion of sky130_fd_sc_hd__decap_12
* 4 abstract devices (width -> parallel min-width fingers)
.subckt DECAPD12 VGND VPWR
XDECAPD12B VGND VGND VPWR VPWR DECAPD12B
.ends DECAPD12

.subckt DECAPD12B VGND VNB VPB VPWR
X0 VPWR VGND VPWR VPB abpmos
X1 VPWR VGND VPWR VPB abpmos
X2 VGND VPWR VGND VNB abnmos
X3 VGND VPWR VGND VNB abnmos
.ends DECAPD12B
