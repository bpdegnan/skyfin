* XOR3D4 : abstract conversion of sky130_fd_sc_hd__xor3_4
* 61 abstract devices (width -> parallel min-width fingers)
.subckt XOR3D4 A B C VGND VPWR X
XXOR3D4B A B C VGND VGND VPWR VPWR X XOR3D4B
.ends XOR3D4

.subckt XOR3D4B A B C VGND VNB VPB VPWR X
X0 a_602_325# a_1031_297# a_1402_49# VPB abpmos
X1 a_602_325# a_1031_297# a_1402_49# VPB abpmos
X2 a_480_297# C VGND VNB abnmos
X3 a_1402_49# a_1135_365# VGND VNB abnmos
X4 a_1402_49# a_1135_365# VGND VNB abnmos
X5 a_602_325# C a_79_21# VPB abpmos
X6 a_602_325# C a_79_21# VPB abpmos
X7 a_602_325# a_1031_297# a_1135_365# VNB abnmos
X8 a_602_325# a_1031_297# a_1135_365# VNB abnmos
X9 a_608_49# a_1031_297# a_1135_365# VPB abpmos
X10 a_608_49# a_1031_297# a_1135_365# VPB abpmos
X11 X a_79_21# VGND VNB abnmos
X12 X a_79_21# VGND VNB abnmos
X13 a_1135_365# B a_608_49# VNB abnmos
X14 a_1135_365# B a_608_49# VNB abnmos
X15 X a_79_21# VPWR VPB abpmos
X16 X a_79_21# VPWR VPB abpmos
X17 X a_79_21# VPWR VPB abpmos
X18 a_608_49# C a_79_21# VNB abnmos
X19 a_608_49# C a_79_21# VNB abnmos
X20 a_1135_365# A VPWR VPB abpmos
X21 a_1135_365# A VPWR VPB abpmos
X22 a_1135_365# A VPWR VPB abpmos
X23 X a_79_21# VPWR VPB abpmos
X24 X a_79_21# VPWR VPB abpmos
X25 X a_79_21# VPWR VPB abpmos
X26 X a_79_21# VPWR VPB abpmos
X27 X a_79_21# VPWR VPB abpmos
X28 X a_79_21# VPWR VPB abpmos
X29 a_608_49# a_1031_297# a_1402_49# VNB abnmos
X30 X a_79_21# VPWR VPB abpmos
X31 X a_79_21# VPWR VPB abpmos
X32 X a_79_21# VPWR VPB abpmos
X33 a_1402_49# B a_608_49# VPB abpmos
X34 a_1402_49# B a_608_49# VPB abpmos
X35 X a_79_21# VGND VNB abnmos
X36 X a_79_21# VGND VNB abnmos
X37 a_1031_297# B VGND VNB abnmos
X38 a_1031_297# B VGND VNB abnmos
X39 a_480_297# C VPWR VPB abpmos
X40 a_480_297# C VPWR VPB abpmos
X41 X a_79_21# VGND VNB abnmos
X42 X a_79_21# VGND VNB abnmos
X43 X a_79_21# VGND VNB abnmos
X44 X a_79_21# VGND VNB abnmos
X45 a_79_21# a_480_297# a_602_325# VNB abnmos
X46 a_79_21# a_480_297# a_602_325# VNB abnmos
X47 a_1402_49# B a_602_325# VNB abnmos
X48 a_1402_49# B a_602_325# VNB abnmos
X49 a_1135_365# A VGND VNB abnmos
X50 a_1135_365# A VGND VNB abnmos
X51 a_1135_365# B a_602_325# VPB abpmos
X52 a_1135_365# B a_602_325# VPB abpmos
X53 a_1031_297# B VPWR VPB abpmos
X54 a_1031_297# B VPWR VPB abpmos
X55 a_1031_297# B VPWR VPB abpmos
X56 a_1402_49# a_1135_365# VPWR VPB abpmos
X57 a_1402_49# a_1135_365# VPWR VPB abpmos
X58 a_1402_49# a_1135_365# VPWR VPB abpmos
X59 a_79_21# a_480_297# a_608_49# VPB abpmos
X60 a_79_21# a_480_297# a_608_49# VPB abpmos
.ends XOR3D4B
