* O221AID4 : abstract conversion of sky130_fd_sc_hd__o221ai_4
* 100 abstract devices (width -> parallel min-width fingers)
.subckt O221AID4 A1 A2 B1 B2 C1 VGND VPWR Y
XO221AID4B A1 A2 B1 B2 C1 VGND VGND VPWR VPWR Y O221AID4B
.ends O221AID4

.subckt O221AID4B A1 A2 B1 B2 C1 VGND VNB VPB VPWR Y
X0 Y B2 a_553_297# VPB abpmos
X1 Y B2 a_553_297# VPB abpmos
X2 Y B2 a_553_297# VPB abpmos
X3 Y C1 a_27_47# VNB abnmos
X4 Y C1 a_27_47# VNB abnmos
X5 a_27_47# B1 a_471_47# VNB abnmos
X6 a_27_47# B1 a_471_47# VNB abnmos
X7 a_471_47# A2 VGND VNB abnmos
X8 a_471_47# A2 VGND VNB abnmos
X9 Y C1 VPWR VPB abpmos
X10 Y C1 VPWR VPB abpmos
X11 Y C1 VPWR VPB abpmos
X12 a_471_47# B1 a_27_47# VNB abnmos
X13 a_471_47# B1 a_27_47# VNB abnmos
X14 Y C1 VPWR VPB abpmos
X15 Y C1 VPWR VPB abpmos
X16 Y C1 VPWR VPB abpmos
X17 a_553_297# B2 Y VPB abpmos
X18 a_553_297# B2 Y VPB abpmos
X19 a_553_297# B2 Y VPB abpmos
X20 a_1241_297# A1 VPWR VPB abpmos
X21 a_1241_297# A1 VPWR VPB abpmos
X22 a_1241_297# A1 VPWR VPB abpmos
X23 a_553_297# B2 Y VPB abpmos
X24 a_553_297# B2 Y VPB abpmos
X25 a_553_297# B2 Y VPB abpmos
X26 a_27_47# C1 Y VNB abnmos
X27 a_27_47# C1 Y VNB abnmos
X28 a_471_47# B1 a_27_47# VNB abnmos
X29 a_471_47# B1 a_27_47# VNB abnmos
X30 a_471_47# A1 VGND VNB abnmos
X31 a_471_47# A1 VGND VNB abnmos
X32 Y C1 VPWR VPB abpmos
X33 Y C1 VPWR VPB abpmos
X34 Y C1 VPWR VPB abpmos
X35 a_553_297# B1 VPWR VPB abpmos
X36 a_553_297# B1 VPWR VPB abpmos
X37 a_553_297# B1 VPWR VPB abpmos
X38 Y C1 VPWR VPB abpmos
X39 Y C1 VPWR VPB abpmos
X40 Y C1 VPWR VPB abpmos
X41 a_27_47# C1 Y VNB abnmos
X42 a_27_47# C1 Y VNB abnmos
X43 Y A2 a_1241_297# VPB abpmos
X44 Y A2 a_1241_297# VPB abpmos
X45 Y A2 a_1241_297# VPB abpmos
X46 Y A2 a_1241_297# VPB abpmos
X47 Y A2 a_1241_297# VPB abpmos
X48 Y A2 a_1241_297# VPB abpmos
X49 a_471_47# A2 VGND VNB abnmos
X50 a_471_47# A2 VGND VNB abnmos
X51 a_471_47# A1 VGND VNB abnmos
X52 a_471_47# A1 VGND VNB abnmos
X53 a_1241_297# A1 VPWR VPB abpmos
X54 a_1241_297# A1 VPWR VPB abpmos
X55 a_1241_297# A1 VPWR VPB abpmos
X56 a_27_47# B2 a_471_47# VNB abnmos
X57 a_27_47# B2 a_471_47# VNB abnmos
X58 a_1241_297# A2 Y VPB abpmos
X59 a_1241_297# A2 Y VPB abpmos
X60 a_1241_297# A2 Y VPB abpmos
X61 a_1241_297# A2 Y VPB abpmos
X62 a_1241_297# A2 Y VPB abpmos
X63 a_1241_297# A2 Y VPB abpmos
X64 Y C1 a_27_47# VNB abnmos
X65 Y C1 a_27_47# VNB abnmos
X66 a_27_47# B1 a_471_47# VNB abnmos
X67 a_27_47# B1 a_471_47# VNB abnmos
X68 a_471_47# A2 VGND VNB abnmos
X69 a_471_47# A2 VGND VNB abnmos
X70 a_471_47# A1 VGND VNB abnmos
X71 a_471_47# A1 VGND VNB abnmos
X72 a_553_297# B1 VPWR VPB abpmos
X73 a_553_297# B1 VPWR VPB abpmos
X74 a_553_297# B1 VPWR VPB abpmos
X75 a_1241_297# A1 VPWR VPB abpmos
X76 a_1241_297# A1 VPWR VPB abpmos
X77 a_1241_297# A1 VPWR VPB abpmos
X78 a_553_297# B1 VPWR VPB abpmos
X79 a_553_297# B1 VPWR VPB abpmos
X80 a_553_297# B1 VPWR VPB abpmos
X81 a_471_47# A1 VGND VNB abnmos
X82 a_471_47# A1 VGND VNB abnmos
X83 Y B2 a_553_297# VPB abpmos
X84 Y B2 a_553_297# VPB abpmos
X85 Y B2 a_553_297# VPB abpmos
X86 a_1241_297# A1 VPWR VPB abpmos
X87 a_1241_297# A1 VPWR VPB abpmos
X88 a_1241_297# A1 VPWR VPB abpmos
X89 a_471_47# B2 a_27_47# VNB abnmos
X90 a_471_47# B2 a_27_47# VNB abnmos
X91 a_553_297# B1 VPWR VPB abpmos
X92 a_553_297# B1 VPWR VPB abpmos
X93 a_553_297# B1 VPWR VPB abpmos
X94 a_471_47# B2 a_27_47# VNB abnmos
X95 a_471_47# B2 a_27_47# VNB abnmos
X96 a_471_47# A2 VGND VNB abnmos
X97 a_471_47# A2 VGND VNB abnmos
X98 a_27_47# B2 a_471_47# VNB abnmos
X99 a_27_47# B2 a_471_47# VNB abnmos
.ends O221AID4B
