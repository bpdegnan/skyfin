* A31OD1 : abstract conversion of sky130_fd_sc_hd__a31o_1
* 25 abstract devices (width -> parallel min-width fingers)
.subckt A31OD1 A1 A2 A3 B1 VGND VPWR X
XA31OD1B A1 A2 A3 B1 VGND VGND VPWR VPWR X A31OD1B
.ends A31OD1

.subckt A31OD1B A1 A2 A3 B1 VGND VNB VPB VPWR X
X0 a_80_21# B1 VGND VNB abnmos
X1 a_80_21# B1 VGND VNB abnmos
X2 X a_80_21# VPWR VPB abpmos
X3 X a_80_21# VPWR VPB abpmos
X4 X a_80_21# VPWR VPB abpmos
X5 a_209_47# A2 a_303_47# VNB abnmos
X6 a_209_47# A2 a_303_47# VNB abnmos
X7 X a_80_21# VGND VNB abnmos
X8 X a_80_21# VGND VNB abnmos
X9 a_303_47# A1 a_80_21# VNB abnmos
X10 a_303_47# A1 a_80_21# VNB abnmos
X11 a_209_297# A1 VPWR VPB abpmos
X12 a_209_297# A1 VPWR VPB abpmos
X13 a_209_297# A1 VPWR VPB abpmos
X14 a_209_297# B1 a_80_21# VPB abpmos
X15 a_209_297# B1 a_80_21# VPB abpmos
X16 a_209_297# B1 a_80_21# VPB abpmos
X17 a_209_47# A3 VGND VNB abnmos
X18 a_209_47# A3 VGND VNB abnmos
X19 a_209_297# A2 VPWR VPB abpmos
X20 a_209_297# A2 VPWR VPB abpmos
X21 a_209_297# A2 VPWR VPB abpmos
X22 a_209_297# A3 VPWR VPB abpmos
X23 a_209_297# A3 VPWR VPB abpmos
X24 a_209_297# A3 VPWR VPB abpmos
.ends A31OD1B
