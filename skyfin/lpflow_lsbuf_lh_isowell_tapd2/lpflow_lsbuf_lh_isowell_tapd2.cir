* LPFLOW_LSBUF_LH_ISOWELL_TAPD2 : abstract conversion of sky130_fd_sc_hd__lpflow_lsbuf_lh_isowell_tap_2
* 38 abstract devices (width -> parallel min-width fingers) ; secondary power ['LOWLVPWR'] collapsed onto VPWR
.subckt LPFLOW_LSBUF_LH_ISOWELL_TAPD2 A VGND VPWR X
XLPFLOW_LSBUF_LH_ISOWELL_TAPD2B A VPWR VGND VPWR VPWR X LPFLOW_LSBUF_LH_ISOWELL_TAPD2B
.ends LPFLOW_LSBUF_LH_ISOWELL_TAPD2

.subckt LPFLOW_LSBUF_LH_ISOWELL_TAPD2B A LOWLVPWR VGND VPB VPWR X
X0 X a_1032_911# VGND VGND abnmos
X1 X a_1032_911# VGND VGND abnmos
X2 X a_1032_911# VPWR VPB abpmos
X3 X a_1032_911# VPWR VPB abpmos
X4 X a_1032_911# VPWR VPB abpmos
X5 X a_1032_911# VGND VGND abnmos
X6 X a_1032_911# VGND VGND abnmos
X7 a_714_47# a_620_911# VPWR VPB abpmos
X8 a_714_47# a_620_911# VPWR VPB abpmos
X9 a_620_911# a_505_297# VGND VGND abnmos
X10 a_620_911# a_505_297# VGND VGND abnmos
X11 a_620_911# a_505_297# VGND VGND abnmos
X12 a_620_911# a_505_297# VGND VGND abnmos
X13 a_714_47# A VGND VGND abnmos
X14 a_714_47# A VGND VGND abnmos
X15 LOWLVPWR A a_505_297# LOWLVPWR abpmos
X16 LOWLVPWR A a_505_297# LOWLVPWR abpmos
X17 LOWLVPWR A a_505_297# LOWLVPWR abpmos
X18 a_714_47# A VGND VGND abnmos
X19 a_714_47# A VGND VGND abnmos
X20 X a_1032_911# VPWR VPB abpmos
X21 X a_1032_911# VPWR VPB abpmos
X22 X a_1032_911# VPWR VPB abpmos
X23 a_1032_911# a_620_911# VPWR VPB abpmos
X24 a_1032_911# a_620_911# VPWR VPB abpmos
X25 a_620_911# a_505_297# VGND VGND abnmos
X26 a_620_911# a_505_297# VGND VGND abnmos
X27 a_620_911# a_505_297# VGND VGND abnmos
X28 a_620_911# a_505_297# VGND VGND abnmos
X29 a_714_47# A VGND VGND abnmos
X30 a_714_47# A VGND VGND abnmos
X31 a_714_47# A VGND VGND abnmos
X32 a_714_47# A VGND VGND abnmos
X33 a_1032_911# a_620_911# VGND VGND abnmos
X34 a_1032_911# a_620_911# VGND VGND abnmos
X35 a_620_911# a_714_47# VPWR VPB abpmos
X36 a_620_911# a_714_47# VPWR VPB abpmos
X37 a_505_297# A VGND VGND abnmos
.ends LPFLOW_LSBUF_LH_ISOWELL_TAPD2B
