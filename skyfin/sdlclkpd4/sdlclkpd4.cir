* SDLCLKPD4 : abstract conversion of sky130_fd_sc_hd__sdlclkp_4
* 53 abstract devices (width -> parallel min-width fingers)
.subckt SDLCLKPD4 CLK GATE SCE VGND VPWR GCLK
XSDLCLKPD4B CLK GATE SCE VGND VGND VPWR VPWR GCLK SDLCLKPD4B
.ends SDLCLKPD4

.subckt SDLCLKPD4B CLK GATE SCE VGND VNB VPB VPWR GCLK
X0 GCLK a_1045_47# VPWR VPB abpmos
X1 GCLK a_1045_47# VPWR VPB abpmos
X2 GCLK a_1045_47# VPWR VPB abpmos
X3 a_383_413# a_465_315# VPWR VPB abpmos
X4 GCLK a_1045_47# VPWR VPB abpmos
X5 GCLK a_1045_47# VPWR VPB abpmos
X6 GCLK a_1045_47# VPWR VPB abpmos
X7 a_465_315# a_287_413# VGND VNB abnmos
X8 a_465_315# a_287_413# VGND VNB abnmos
X9 a_257_147# CLK VPWR VPB abpmos
X10 a_257_147# CLK VPWR VPB abpmos
X11 GCLK a_1045_47# VGND VNB abnmos
X12 GCLK a_1045_47# VGND VNB abnmos
X13 a_1045_47# a_465_315# VPWR VPB abpmos
X14 a_1045_47# a_465_315# VPWR VPB abpmos
X15 a_1045_47# a_465_315# VPWR VPB abpmos
X16 GCLK a_1045_47# VPWR VPB abpmos
X17 GCLK a_1045_47# VPWR VPB abpmos
X18 GCLK a_1045_47# VPWR VPB abpmos
X19 a_395_47# a_465_315# VGND VNB abnmos
X20 a_27_47# a_257_147# a_287_413# VNB abnmos
X21 a_1127_47# CLK VGND VNB abnmos
X22 a_1127_47# CLK VGND VNB abnmos
X23 GCLK a_1045_47# VGND VNB abnmos
X24 GCLK a_1045_47# VGND VNB abnmos
X25 a_27_47# a_257_243# a_287_413# VPB abpmos
X26 a_1045_47# CLK VPWR VPB abpmos
X27 a_1045_47# CLK VPWR VPB abpmos
X28 a_1045_47# CLK VPWR VPB abpmos
X29 a_287_413# a_257_147# a_383_413# VPB abpmos
X30 a_287_413# a_257_243# a_395_47# VNB abnmos
X31 a_257_147# CLK VGND VNB abnmos
X32 a_257_243# a_257_147# VPWR VPB abpmos
X33 a_257_243# a_257_147# VPWR VPB abpmos
X34 a_465_315# a_287_413# VPWR VPB abpmos
X35 a_465_315# a_287_413# VPWR VPB abpmos
X36 a_465_315# a_287_413# VPWR VPB abpmos
X37 a_257_243# a_257_147# VGND VNB abnmos
X38 a_1045_47# a_465_315# a_1127_47# VNB abnmos
X39 a_1045_47# a_465_315# a_1127_47# VNB abnmos
X40 GCLK a_1045_47# VGND VNB abnmos
X41 GCLK a_1045_47# VGND VNB abnmos
X42 a_109_369# SCE VPWR VPB abpmos
X43 a_109_369# SCE VPWR VPB abpmos
X44 a_27_47# GATE VGND VNB abnmos
X45 a_27_47# SCE VGND VNB abnmos
X46 a_109_369# GATE a_27_47# VPB abpmos
X47 a_109_369# GATE a_27_47# VPB abpmos
X48 GCLK a_1045_47# VPWR VPB abpmos
X49 GCLK a_1045_47# VPWR VPB abpmos
X50 GCLK a_1045_47# VPWR VPB abpmos
X51 GCLK a_1045_47# VGND VNB abnmos
X52 GCLK a_1045_47# VGND VNB abnmos
.ends SDLCLKPD4B
