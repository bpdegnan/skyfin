* auto-generated runcell for SDLCLKPD4
* NOTE: sequential cell -- combinational sweep only, not a functional test
.lib "$SPICE_LIB/sky130.lib.spice" tt
.include "$SPICE_DEVICES/devices.cir"
.include "sdlclkpd4.cir"

.param pvdd=1.8V
VVPWR VDD 0 {pvdd}
V_GND VGND 0 0

V_SCE SCE 0 PWL( 0ns 0 10ns 0 10.1ns {pvdd} 20ns {pvdd} 20.1ns 0 30ns 0 30.1ns {pvdd} 40ns {pvdd} 40.1ns 0 50ns 0 50.1ns {pvdd} 60ns {pvdd} 60.1ns 0 70ns 0 70.1ns {pvdd} 80ns {pvdd} )
V_GATE GATE 0 PWL( 0ns 0 20ns 0 20.1ns {pvdd} 40ns {pvdd} 40.1ns 0 60ns 0 60.1ns {pvdd} 80ns {pvdd} )
V_CLK CLK 0 PWL( 0ns 0 40ns 0 40.1ns {pvdd} 80ns {pvdd} )

X1 CLK GATE SCE VGND VDD GCLK SDLCLKPD4
CL_GCLK GCLK VGND 0.1f

.control
tran 0.05n 80n
wrdata result.raw v(SCE) v(GATE) v(CLK) v(GCLK)
.endc
.end
