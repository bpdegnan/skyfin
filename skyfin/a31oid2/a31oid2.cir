* A31OID2 : abstract conversion of sky130_fd_sc_hd__a31oi_2
* 40 abstract devices (width -> parallel min-width fingers)
.subckt A31OID2 A1 A2 A3 B1 VGND VPWR Y
XA31OID2B A1 A2 A3 B1 VGND VGND VPWR VPWR Y A31OID2B
.ends A31OID2

.subckt A31OID2B A1 A2 A3 B1 VGND VNB VPB VPWR Y
X0 a_277_47# A2 a_27_47# VNB abnmos
X1 a_277_47# A2 a_27_47# VNB abnmos
X2 a_27_297# B1 Y VPB abpmos
X3 a_27_297# B1 Y VPB abpmos
X4 a_27_297# B1 Y VPB abpmos
X5 Y B1 VGND VNB abnmos
X6 Y B1 VGND VNB abnmos
X7 a_277_47# A1 Y VNB abnmos
X8 a_277_47# A1 Y VNB abnmos
X9 Y B1 a_27_297# VPB abpmos
X10 Y B1 a_27_297# VPB abpmos
X11 Y B1 a_27_297# VPB abpmos
X12 a_27_47# A2 a_277_47# VNB abnmos
X13 a_27_47# A2 a_277_47# VNB abnmos
X14 Y A1 a_277_47# VNB abnmos
X15 Y A1 a_277_47# VNB abnmos
X16 a_27_297# A1 VPWR VPB abpmos
X17 a_27_297# A1 VPWR VPB abpmos
X18 a_27_297# A1 VPWR VPB abpmos
X19 a_27_47# A3 VGND VNB abnmos
X20 a_27_47# A3 VGND VNB abnmos
X21 a_27_297# A2 VPWR VPB abpmos
X22 a_27_297# A2 VPWR VPB abpmos
X23 a_27_297# A2 VPWR VPB abpmos
X24 a_27_47# A3 VGND VNB abnmos
X25 a_27_47# A3 VGND VNB abnmos
X26 a_27_297# A1 VPWR VPB abpmos
X27 a_27_297# A1 VPWR VPB abpmos
X28 a_27_297# A1 VPWR VPB abpmos
X29 a_27_297# A3 VPWR VPB abpmos
X30 a_27_297# A3 VPWR VPB abpmos
X31 a_27_297# A3 VPWR VPB abpmos
X32 a_27_297# A3 VPWR VPB abpmos
X33 a_27_297# A3 VPWR VPB abpmos
X34 a_27_297# A3 VPWR VPB abpmos
X35 a_27_297# A2 VPWR VPB abpmos
X36 a_27_297# A2 VPWR VPB abpmos
X37 a_27_297# A2 VPWR VPB abpmos
X38 Y B1 VGND VNB abnmos
X39 Y B1 VGND VNB abnmos
.ends A31OID2B
