* AND4D4 : abstract conversion of sky130_fd_sc_hd__and4_4
* 40 abstract devices (width -> parallel min-width fingers)
.subckt AND4D4 A B C D VGND VPWR X
XAND4D4B A B C D VGND VGND VPWR VPWR X AND4D4B
.ends AND4D4

.subckt AND4D4B A B C D VGND VNB VPB VPWR X
X0 a_27_47# D VPWR VPB abpmos
X1 a_27_47# D VPWR VPB abpmos
X2 a_27_47# D VPWR VPB abpmos
X3 X a_27_47# VGND VNB abnmos
X4 X a_27_47# VGND VNB abnmos
X5 a_285_47# D VGND VNB abnmos
X6 a_285_47# D VGND VNB abnmos
X7 X a_27_47# VGND VNB abnmos
X8 X a_27_47# VGND VNB abnmos
X9 a_109_47# B a_188_47# VNB abnmos
X10 a_109_47# B a_188_47# VNB abnmos
X11 a_27_47# C VPWR VPB abpmos
X12 a_27_47# C VPWR VPB abpmos
X13 a_27_47# C VPWR VPB abpmos
X14 X a_27_47# VGND VNB abnmos
X15 X a_27_47# VGND VNB abnmos
X16 X a_27_47# VPWR VPB abpmos
X17 X a_27_47# VPWR VPB abpmos
X18 X a_27_47# VPWR VPB abpmos
X19 X a_27_47# VPWR VPB abpmos
X20 X a_27_47# VPWR VPB abpmos
X21 X a_27_47# VPWR VPB abpmos
X22 a_27_47# A a_109_47# VNB abnmos
X23 a_27_47# A a_109_47# VNB abnmos
X24 X a_27_47# VPWR VPB abpmos
X25 X a_27_47# VPWR VPB abpmos
X26 X a_27_47# VPWR VPB abpmos
X27 a_27_47# A VPWR VPB abpmos
X28 a_27_47# A VPWR VPB abpmos
X29 a_27_47# A VPWR VPB abpmos
X30 a_27_47# B VPWR VPB abpmos
X31 a_27_47# B VPWR VPB abpmos
X32 a_27_47# B VPWR VPB abpmos
X33 X a_27_47# VGND VNB abnmos
X34 X a_27_47# VGND VNB abnmos
X35 X a_27_47# VPWR VPB abpmos
X36 X a_27_47# VPWR VPB abpmos
X37 X a_27_47# VPWR VPB abpmos
X38 a_188_47# C a_285_47# VNB abnmos
X39 a_188_47# C a_285_47# VNB abnmos
.ends AND4D4B
