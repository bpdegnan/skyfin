* A2111OID1 : abstract conversion of sky130_fd_sc_hd__a2111oi_1
* 25 abstract devices (width -> parallel min-width fingers)
.subckt A2111OID1 A1 A2 B1 C1 D1 VGND VPWR Y
XA2111OID1B A1 A2 B1 C1 D1 VGND VGND VPWR VPWR Y A2111OID1B
.ends A2111OID1

.subckt A2111OID1B A1 A2 B1 C1 D1 VGND VNB VPB VPWR Y
X0 Y C1 VGND VNB abnmos
X1 Y C1 VGND VNB abnmos
X2 Y B1 VGND VNB abnmos
X3 Y B1 VGND VNB abnmos
X4 a_316_297# B1 a_420_297# VPB abpmos
X5 a_316_297# B1 a_420_297# VPB abpmos
X6 a_316_297# B1 a_420_297# VPB abpmos
X7 Y A1 a_568_47# VNB abnmos
X8 Y A1 a_568_47# VNB abnmos
X9 Y D1 a_217_297# VPB abpmos
X10 Y D1 a_217_297# VPB abpmos
X11 Y D1 a_217_297# VPB abpmos
X12 a_420_297# A1 VPWR VPB abpmos
X13 a_420_297# A1 VPWR VPB abpmos
X14 a_420_297# A1 VPWR VPB abpmos
X15 a_568_47# A2 VGND VNB abnmos
X16 a_568_47# A2 VGND VNB abnmos
X17 Y D1 VGND VNB abnmos
X18 Y D1 VGND VNB abnmos
X19 a_217_297# C1 a_316_297# VPB abpmos
X20 a_217_297# C1 a_316_297# VPB abpmos
X21 a_217_297# C1 a_316_297# VPB abpmos
X22 a_420_297# A2 VPWR VPB abpmos
X23 a_420_297# A2 VPWR VPB abpmos
X24 a_420_297# A2 VPWR VPB abpmos
.ends A2111OID1B
