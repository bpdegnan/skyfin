* MUX4D2 : abstract conversion of sky130_fd_sc_hd__mux4_2
* 42 abstract devices (width -> parallel min-width fingers)
.subckt MUX4D2 A0 A1 A2 A3 S0 S1 VGND VPWR X
XMUX4D2B A0 A1 A2 A3 S0 S1 VGND VGND VPWR VPWR X MUX4D2B
.ends MUX4D2

.subckt MUX4D2B A0 A1 A2 A3 S0 S1 VGND VNB VPB VPWR X
X0 a_1060_369# A1 VPWR VPB abpmos
X1 a_1060_369# A1 VPWR VPB abpmos
X2 a_193_47# a_27_47# a_288_47# VNB abnmos
X3 X a_788_316# VPWR VPB abpmos
X4 X a_788_316# VPWR VPB abpmos
X5 X a_788_316# VPWR VPB abpmos
X6 a_1279_413# A0 VPWR VPB abpmos
X7 a_1279_413# A0 VPWR VPB abpmos
X8 X a_788_316# VGND VNB abnmos
X9 X a_788_316# VGND VNB abnmos
X10 X a_788_316# VPWR VPB abpmos
X11 X a_788_316# VPWR VPB abpmos
X12 X a_788_316# VPWR VPB abpmos
X13 a_288_47# S1 a_788_316# VNB abnmos
X14 a_193_369# S0 a_288_47# VPB abpmos
X15 a_372_413# A3 VPWR VPB abpmos
X16 a_372_413# A3 VPWR VPB abpmos
X17 a_872_316# a_27_47# a_1281_47# VNB abnmos
X18 a_288_47# a_27_47# a_372_413# VPB abpmos
X19 a_1064_47# A1 VGND VNB abnmos
X20 a_600_345# S1 VPWR VPB abpmos
X21 a_600_345# S1 VPWR VPB abpmos
X22 a_872_316# S0 a_1279_413# VPB abpmos
X23 a_27_47# S0 VPWR VPB abpmos
X24 a_27_47# S0 VPWR VPB abpmos
X25 a_193_369# A2 VPWR VPB abpmos
X26 a_193_369# A2 VPWR VPB abpmos
X27 a_193_47# A2 VGND VNB abnmos
X28 a_288_47# a_600_345# a_788_316# VPB abpmos
X29 a_288_47# a_600_345# a_788_316# VPB abpmos
X30 a_397_47# A3 VGND VNB abnmos
X31 a_27_47# S0 VGND VNB abnmos
X32 a_1060_369# a_27_47# a_872_316# VPB abpmos
X33 a_600_345# S1 VGND VNB abnmos
X34 a_1281_47# A0 VGND VNB abnmos
X35 X a_788_316# VGND VNB abnmos
X36 X a_788_316# VGND VNB abnmos
X37 a_288_47# S0 a_397_47# VNB abnmos
X38 a_788_316# S1 a_872_316# VPB abpmos
X39 a_788_316# S1 a_872_316# VPB abpmos
X40 a_788_316# a_600_345# a_872_316# VNB abnmos
X41 a_1064_47# S0 a_872_316# VNB abnmos
.ends MUX4D2B
