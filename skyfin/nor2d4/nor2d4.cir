* NOR2D4 : abstract conversion of sky130_fd_sc_hd__nor2_4
* 40 abstract devices (width -> parallel min-width fingers)
.subckt NOR2D4 A B VGND VPWR Y
XNOR2D4B A B VGND VGND VPWR VPWR Y NOR2D4B
.ends NOR2D4

.subckt NOR2D4B A B VGND VNB VPB VPWR Y
X0 a_27_297# B Y VPB abpmos
X1 a_27_297# B Y VPB abpmos
X2 a_27_297# B Y VPB abpmos
X3 Y A VGND VNB abnmos
X4 Y A VGND VNB abnmos
X5 a_27_297# A VPWR VPB abpmos
X6 a_27_297# A VPWR VPB abpmos
X7 a_27_297# A VPWR VPB abpmos
X8 a_27_297# A VPWR VPB abpmos
X9 a_27_297# A VPWR VPB abpmos
X10 a_27_297# A VPWR VPB abpmos
X11 Y B a_27_297# VPB abpmos
X12 Y B a_27_297# VPB abpmos
X13 Y B a_27_297# VPB abpmos
X14 Y A VGND VNB abnmos
X15 Y A VGND VNB abnmos
X16 a_27_297# A VPWR VPB abpmos
X17 a_27_297# A VPWR VPB abpmos
X18 a_27_297# A VPWR VPB abpmos
X19 a_27_297# A VPWR VPB abpmos
X20 a_27_297# A VPWR VPB abpmos
X21 a_27_297# A VPWR VPB abpmos
X22 Y A VGND VNB abnmos
X23 Y A VGND VNB abnmos
X24 Y B VGND VNB abnmos
X25 Y B VGND VNB abnmos
X26 a_27_297# B Y VPB abpmos
X27 a_27_297# B Y VPB abpmos
X28 a_27_297# B Y VPB abpmos
X29 Y A VGND VNB abnmos
X30 Y A VGND VNB abnmos
X31 Y B VGND VNB abnmos
X32 Y B VGND VNB abnmos
X33 Y B a_27_297# VPB abpmos
X34 Y B a_27_297# VPB abpmos
X35 Y B a_27_297# VPB abpmos
X36 Y B VGND VNB abnmos
X37 Y B VGND VNB abnmos
X38 Y B VGND VNB abnmos
X39 Y B VGND VNB abnmos
.ends NOR2D4B
