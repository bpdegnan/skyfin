* DFSTPD2 : abstract conversion of sky130_fd_sc_hd__dfstp_2
* 49 abstract devices (width -> parallel min-width fingers)
.subckt DFSTPD2 CLK D SET_B VGND VPWR Q
XDFSTPD2B CLK D SET_B VGND VGND VPWR VPWR Q DFSTPD2B
.ends DFSTPD2

.subckt DFSTPD2B CLK D SET_B VGND VNB VPB VPWR Q
X0 a_562_413# a_652_21# VPWR VPB abpmos
X1 a_956_413# a_27_47# a_1028_413# VPB abpmos
X2 a_1300_47# SET_B VGND VNB abnmos
X3 a_381_47# a_193_47# a_476_47# VPB abpmos
X4 Q a_1602_47# VGND VNB abnmos
X5 Q a_1602_47# VGND VNB abnmos
X6 a_1028_413# a_193_47# a_1136_413# VPB abpmos
X7 Q a_1602_47# VPWR VPB abpmos
X8 Q a_1602_47# VPWR VPB abpmos
X9 Q a_1602_47# VPWR VPB abpmos
X10 a_1178_261# a_1028_413# VGND VNB abnmos
X11 a_1178_261# a_1028_413# VGND VNB abnmos
X12 a_476_47# a_27_47# a_562_413# VPB abpmos
X13 a_381_47# a_27_47# a_476_47# VNB abnmos
X14 a_1056_47# a_476_47# VGND VNB abnmos
X15 a_1028_413# SET_B VPWR VPB abpmos
X16 a_1602_47# a_1028_413# VPWR VPB abpmos
X17 a_1602_47# a_1028_413# VPWR VPB abpmos
X18 a_1602_47# a_1028_413# VPWR VPB abpmos
X19 a_1602_47# a_1028_413# VGND VNB abnmos
X20 a_1602_47# a_1028_413# VGND VNB abnmos
X21 Q a_1602_47# VPWR VPB abpmos
X22 Q a_1602_47# VPWR VPB abpmos
X23 Q a_1602_47# VPWR VPB abpmos
X24 a_1056_47# a_193_47# a_1028_413# VNB abnmos
X25 a_1228_47# a_1178_261# a_1300_47# VNB abnmos
X26 a_652_21# SET_B VPWR VPB abpmos
X27 a_796_47# a_476_47# a_652_21# VNB abnmos
X28 a_956_413# a_476_47# VPWR VPB abpmos
X29 a_1178_261# a_1028_413# VPWR VPB abpmos
X30 a_1178_261# a_1028_413# VPWR VPB abpmos
X31 a_586_47# a_652_21# VGND VNB abnmos
X32 a_381_47# D VPWR VPB abpmos
X33 a_381_47# D VPWR VPB abpmos
X34 a_652_21# a_476_47# VPWR VPB abpmos
X35 a_1136_413# a_1178_261# VPWR VPB abpmos
X36 a_476_47# a_193_47# a_586_47# VNB abnmos
X37 a_193_47# a_27_47# VGND VNB abnmos
X38 a_27_47# CLK VGND VNB abnmos
X39 a_27_47# CLK VPWR VPB abpmos
X40 a_27_47# CLK VPWR VPB abpmos
X41 Q a_1602_47# VGND VNB abnmos
X42 Q a_1602_47# VGND VNB abnmos
X43 a_193_47# a_27_47# VPWR VPB abpmos
X44 a_193_47# a_27_47# VPWR VPB abpmos
X45 a_381_47# D VGND VNB abnmos
X46 a_381_47# D VGND VNB abnmos
X47 a_796_47# SET_B VGND VNB abnmos
X48 a_1028_413# a_27_47# a_1228_47# VNB abnmos
.ends DFSTPD2B
