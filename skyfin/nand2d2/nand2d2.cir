* NAND2D2 : abstract conversion of sky130_fd_sc_hd__nand2_2
* 20 abstract devices (width -> parallel min-width fingers)
.subckt NAND2D2 A B VGND VPWR Y
XNAND2D2B A B VGND VGND VPWR VPWR Y NAND2D2B
.ends NAND2D2

.subckt NAND2D2B A B VGND VNB VPB VPWR Y
X0 Y A a_27_47# VNB abnmos
X1 Y A a_27_47# VNB abnmos
X2 a_27_47# A Y VNB abnmos
X3 a_27_47# A Y VNB abnmos
X4 a_27_47# B VGND VNB abnmos
X5 a_27_47# B VGND VNB abnmos
X6 Y A VPWR VPB abpmos
X7 Y A VPWR VPB abpmos
X8 Y A VPWR VPB abpmos
X9 a_27_47# B VGND VNB abnmos
X10 a_27_47# B VGND VNB abnmos
X11 Y B VPWR VPB abpmos
X12 Y B VPWR VPB abpmos
X13 Y B VPWR VPB abpmos
X14 Y B VPWR VPB abpmos
X15 Y B VPWR VPB abpmos
X16 Y B VPWR VPB abpmos
X17 Y A VPWR VPB abpmos
X18 Y A VPWR VPB abpmos
X19 Y A VPWR VPB abpmos
.ends NAND2D2B
