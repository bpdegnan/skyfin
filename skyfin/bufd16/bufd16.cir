* BUFD16 : abstract conversion of sky130_fd_sc_hd__buf_16
* 110 abstract devices (width -> parallel min-width fingers)
.subckt BUFD16 A VGND VPWR X
XBUFD16B A VGND VGND VPWR VPWR X BUFD16B
.ends BUFD16

.subckt BUFD16B A VGND VNB VPB VPWR X
X0 X a_109_47# VPWR VPB abpmos
X1 X a_109_47# VPWR VPB abpmos
X2 X a_109_47# VPWR VPB abpmos
X3 X a_109_47# VPWR VPB abpmos
X4 X a_109_47# VPWR VPB abpmos
X5 X a_109_47# VPWR VPB abpmos
X6 X a_109_47# VGND VNB abnmos
X7 X a_109_47# VGND VNB abnmos
X8 a_109_47# A VGND VNB abnmos
X9 a_109_47# A VGND VNB abnmos
X10 X a_109_47# VGND VNB abnmos
X11 X a_109_47# VGND VNB abnmos
X12 X a_109_47# VPWR VPB abpmos
X13 X a_109_47# VPWR VPB abpmos
X14 X a_109_47# VPWR VPB abpmos
X15 a_109_47# A VPWR VPB abpmos
X16 a_109_47# A VPWR VPB abpmos
X17 a_109_47# A VPWR VPB abpmos
X18 X a_109_47# VGND VNB abnmos
X19 X a_109_47# VGND VNB abnmos
X20 X a_109_47# VPWR VPB abpmos
X21 X a_109_47# VPWR VPB abpmos
X22 X a_109_47# VPWR VPB abpmos
X23 a_109_47# A VGND VNB abnmos
X24 a_109_47# A VGND VNB abnmos
X25 X a_109_47# VPWR VPB abpmos
X26 X a_109_47# VPWR VPB abpmos
X27 X a_109_47# VPWR VPB abpmos
X28 X a_109_47# VGND VNB abnmos
X29 X a_109_47# VGND VNB abnmos
X30 X a_109_47# VPWR VPB abpmos
X31 X a_109_47# VPWR VPB abpmos
X32 X a_109_47# VPWR VPB abpmos
X33 X a_109_47# VGND VNB abnmos
X34 X a_109_47# VGND VNB abnmos
X35 X a_109_47# VPWR VPB abpmos
X36 X a_109_47# VPWR VPB abpmos
X37 X a_109_47# VPWR VPB abpmos
X38 X a_109_47# VPWR VPB abpmos
X39 X a_109_47# VPWR VPB abpmos
X40 X a_109_47# VPWR VPB abpmos
X41 X a_109_47# VPWR VPB abpmos
X42 X a_109_47# VPWR VPB abpmos
X43 X a_109_47# VPWR VPB abpmos
X44 X a_109_47# VPWR VPB abpmos
X45 X a_109_47# VPWR VPB abpmos
X46 X a_109_47# VPWR VPB abpmos
X47 a_109_47# A VGND VNB abnmos
X48 a_109_47# A VGND VNB abnmos
X49 X a_109_47# VPWR VPB abpmos
X50 X a_109_47# VPWR VPB abpmos
X51 X a_109_47# VPWR VPB abpmos
X52 X a_109_47# VGND VNB abnmos
X53 X a_109_47# VGND VNB abnmos
X54 X a_109_47# VGND VNB abnmos
X55 X a_109_47# VGND VNB abnmos
X56 X a_109_47# VPWR VPB abpmos
X57 X a_109_47# VPWR VPB abpmos
X58 X a_109_47# VPWR VPB abpmos
X59 X a_109_47# VGND VNB abnmos
X60 X a_109_47# VGND VNB abnmos
X61 X a_109_47# VGND VNB abnmos
X62 X a_109_47# VGND VNB abnmos
X63 X a_109_47# VPWR VPB abpmos
X64 X a_109_47# VPWR VPB abpmos
X65 X a_109_47# VPWR VPB abpmos
X66 X a_109_47# VGND VNB abnmos
X67 X a_109_47# VGND VNB abnmos
X68 a_109_47# A VGND VNB abnmos
X69 a_109_47# A VGND VNB abnmos
X70 X a_109_47# VGND VNB abnmos
X71 X a_109_47# VGND VNB abnmos
X72 X a_109_47# VGND VNB abnmos
X73 X a_109_47# VGND VNB abnmos
X74 a_109_47# A VGND VNB abnmos
X75 a_109_47# A VGND VNB abnmos
X76 X a_109_47# VGND VNB abnmos
X77 X a_109_47# VGND VNB abnmos
X78 a_109_47# A VPWR VPB abpmos
X79 a_109_47# A VPWR VPB abpmos
X80 a_109_47# A VPWR VPB abpmos
X81 X a_109_47# VPWR VPB abpmos
X82 X a_109_47# VPWR VPB abpmos
X83 X a_109_47# VPWR VPB abpmos
X84 a_109_47# A VGND VNB abnmos
X85 a_109_47# A VGND VNB abnmos
X86 X a_109_47# VGND VNB abnmos
X87 X a_109_47# VGND VNB abnmos
X88 X a_109_47# VGND VNB abnmos
X89 X a_109_47# VGND VNB abnmos
X90 a_109_47# A VPWR VPB abpmos
X91 a_109_47# A VPWR VPB abpmos
X92 a_109_47# A VPWR VPB abpmos
X93 a_109_47# A VPWR VPB abpmos
X94 a_109_47# A VPWR VPB abpmos
X95 a_109_47# A VPWR VPB abpmos
X96 a_109_47# A VPWR VPB abpmos
X97 a_109_47# A VPWR VPB abpmos
X98 a_109_47# A VPWR VPB abpmos
X99 X a_109_47# VPWR VPB abpmos
X100 X a_109_47# VPWR VPB abpmos
X101 X a_109_47# VPWR VPB abpmos
X102 X a_109_47# VPWR VPB abpmos
X103 X a_109_47# VPWR VPB abpmos
X104 X a_109_47# VPWR VPB abpmos
X105 X a_109_47# VGND VNB abnmos
X106 X a_109_47# VGND VNB abnmos
X107 a_109_47# A VPWR VPB abpmos
X108 a_109_47# A VPWR VPB abpmos
X109 a_109_47# A VPWR VPB abpmos
.ends BUFD16B
