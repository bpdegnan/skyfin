* CLKBUFD16 : abstract conversion of sky130_fd_sc_hd__clkbuf_16
* 80 abstract devices (width -> parallel min-width fingers)
.subckt CLKBUFD16 A VGND VPWR X
XCLKBUFD16B A VGND VGND VPWR VPWR X CLKBUFD16B
.ends CLKBUFD16

.subckt CLKBUFD16B A VGND VNB VPB VPWR X
X0 X a_110_47# VPWR VPB abpmos
X1 X a_110_47# VPWR VPB abpmos
X2 X a_110_47# VPWR VPB abpmos
X3 X a_110_47# VGND VNB abnmos
X4 X a_110_47# VGND VNB abnmos
X5 a_110_47# A VPWR VPB abpmos
X6 a_110_47# A VPWR VPB abpmos
X7 a_110_47# A VPWR VPB abpmos
X8 X a_110_47# VPWR VPB abpmos
X9 X a_110_47# VPWR VPB abpmos
X10 X a_110_47# VPWR VPB abpmos
X11 X a_110_47# VPWR VPB abpmos
X12 X a_110_47# VPWR VPB abpmos
X13 X a_110_47# VPWR VPB abpmos
X14 a_110_47# A VGND VNB abnmos
X15 a_110_47# A VPWR VPB abpmos
X16 a_110_47# A VPWR VPB abpmos
X17 a_110_47# A VPWR VPB abpmos
X18 X a_110_47# VGND VNB abnmos
X19 a_110_47# A VGND VNB abnmos
X20 X a_110_47# VGND VNB abnmos
X21 X a_110_47# VGND VNB abnmos
X22 a_110_47# A VPWR VPB abpmos
X23 a_110_47# A VPWR VPB abpmos
X24 a_110_47# A VPWR VPB abpmos
X25 X a_110_47# VPWR VPB abpmos
X26 X a_110_47# VPWR VPB abpmos
X27 X a_110_47# VPWR VPB abpmos
X28 X a_110_47# VGND VNB abnmos
X29 a_110_47# A VPWR VPB abpmos
X30 a_110_47# A VPWR VPB abpmos
X31 a_110_47# A VPWR VPB abpmos
X32 X a_110_47# VGND VNB abnmos
X33 X a_110_47# VGND VNB abnmos
X34 X a_110_47# VGND VNB abnmos
X35 X a_110_47# VGND VNB abnmos
X36 X a_110_47# VPWR VPB abpmos
X37 X a_110_47# VPWR VPB abpmos
X38 X a_110_47# VPWR VPB abpmos
X39 X a_110_47# VPWR VPB abpmos
X40 X a_110_47# VPWR VPB abpmos
X41 X a_110_47# VPWR VPB abpmos
X42 X a_110_47# VPWR VPB abpmos
X43 X a_110_47# VPWR VPB abpmos
X44 X a_110_47# VPWR VPB abpmos
X45 X a_110_47# VPWR VPB abpmos
X46 X a_110_47# VPWR VPB abpmos
X47 X a_110_47# VPWR VPB abpmos
X48 X a_110_47# VPWR VPB abpmos
X49 X a_110_47# VPWR VPB abpmos
X50 X a_110_47# VPWR VPB abpmos
X51 X a_110_47# VGND VNB abnmos
X52 X a_110_47# VPWR VPB abpmos
X53 X a_110_47# VPWR VPB abpmos
X54 X a_110_47# VPWR VPB abpmos
X55 X a_110_47# VGND VNB abnmos
X56 X a_110_47# VPWR VPB abpmos
X57 X a_110_47# VPWR VPB abpmos
X58 X a_110_47# VPWR VPB abpmos
X59 X a_110_47# VGND VNB abnmos
X60 X a_110_47# VGND VNB abnmos
X61 X a_110_47# VPWR VPB abpmos
X62 X a_110_47# VPWR VPB abpmos
X63 X a_110_47# VPWR VPB abpmos
X64 X a_110_47# VPWR VPB abpmos
X65 X a_110_47# VPWR VPB abpmos
X66 X a_110_47# VPWR VPB abpmos
X67 X a_110_47# VPWR VPB abpmos
X68 X a_110_47# VPWR VPB abpmos
X69 X a_110_47# VPWR VPB abpmos
X70 a_110_47# A VGND VNB abnmos
X71 X a_110_47# VPWR VPB abpmos
X72 X a_110_47# VPWR VPB abpmos
X73 X a_110_47# VPWR VPB abpmos
X74 a_110_47# A VGND VNB abnmos
X75 X a_110_47# VPWR VPB abpmos
X76 X a_110_47# VPWR VPB abpmos
X77 X a_110_47# VPWR VPB abpmos
X78 X a_110_47# VGND VNB abnmos
X79 X a_110_47# VGND VNB abnmos
.ends CLKBUFD16B
