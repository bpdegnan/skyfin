* A41OID4 : abstract conversion of sky130_fd_sc_hd__a41oi_4
* 100 abstract devices (width -> parallel min-width fingers)
.subckt A41OID4 A1 A2 A3 A4 B1 VGND VPWR Y
XA41OID4B A1 A2 A3 A4 B1 VGND VGND VPWR VPWR Y A41OID4B
.ends A41OID4

.subckt A41OID4B A1 A2 A3 A4 B1 VGND VNB VPB VPWR Y
X0 a_27_297# A3 VPWR VPB abpmos
X1 a_27_297# A3 VPWR VPB abpmos
X2 a_27_297# A3 VPWR VPB abpmos
X3 Y A1 a_493_47# VNB abnmos
X4 Y A1 a_493_47# VNB abnmos
X5 a_1269_47# A4 VGND VNB abnmos
X6 a_1269_47# A4 VGND VNB abnmos
X7 Y A1 a_493_47# VNB abnmos
X8 Y A1 a_493_47# VNB abnmos
X9 a_27_297# A3 VPWR VPB abpmos
X10 a_27_297# A3 VPWR VPB abpmos
X11 a_27_297# A3 VPWR VPB abpmos
X12 a_493_47# A1 Y VNB abnmos
X13 a_493_47# A1 Y VNB abnmos
X14 a_27_297# A1 VPWR VPB abpmos
X15 a_27_297# A1 VPWR VPB abpmos
X16 a_27_297# A1 VPWR VPB abpmos
X17 Y B1 VGND VNB abnmos
X18 Y B1 VGND VNB abnmos
X19 a_27_297# A2 VPWR VPB abpmos
X20 a_27_297# A2 VPWR VPB abpmos
X21 a_27_297# A2 VPWR VPB abpmos
X22 a_27_297# A4 VPWR VPB abpmos
X23 a_27_297# A4 VPWR VPB abpmos
X24 a_27_297# A4 VPWR VPB abpmos
X25 a_27_297# A1 VPWR VPB abpmos
X26 a_27_297# A1 VPWR VPB abpmos
X27 a_27_297# A1 VPWR VPB abpmos
X28 a_27_297# A3 VPWR VPB abpmos
X29 a_27_297# A3 VPWR VPB abpmos
X30 a_27_297# A3 VPWR VPB abpmos
X31 a_1269_47# A4 VGND VNB abnmos
X32 a_1269_47# A4 VGND VNB abnmos
X33 a_27_297# A4 VPWR VPB abpmos
X34 a_27_297# A4 VPWR VPB abpmos
X35 a_27_297# A4 VPWR VPB abpmos
X36 a_27_297# A4 VPWR VPB abpmos
X37 a_27_297# A4 VPWR VPB abpmos
X38 a_27_297# A4 VPWR VPB abpmos
X39 a_911_47# A2 a_493_47# VNB abnmos
X40 a_911_47# A2 a_493_47# VNB abnmos
X41 a_911_47# A3 a_1269_47# VNB abnmos
X42 a_911_47# A3 a_1269_47# VNB abnmos
X43 a_27_297# A1 VPWR VPB abpmos
X44 a_27_297# A1 VPWR VPB abpmos
X45 a_27_297# A1 VPWR VPB abpmos
X46 a_27_297# A3 VPWR VPB abpmos
X47 a_27_297# A3 VPWR VPB abpmos
X48 a_27_297# A3 VPWR VPB abpmos
X49 Y B1 VGND VNB abnmos
X50 Y B1 VGND VNB abnmos
X51 a_911_47# A2 a_493_47# VNB abnmos
X52 a_911_47# A2 a_493_47# VNB abnmos
X53 a_911_47# A3 a_1269_47# VNB abnmos
X54 a_911_47# A3 a_1269_47# VNB abnmos
X55 a_27_297# A4 VPWR VPB abpmos
X56 a_27_297# A4 VPWR VPB abpmos
X57 a_27_297# A4 VPWR VPB abpmos
X58 a_493_47# A2 a_911_47# VNB abnmos
X59 a_493_47# A2 a_911_47# VNB abnmos
X60 a_493_47# A1 Y VNB abnmos
X61 a_493_47# A1 Y VNB abnmos
X62 a_1269_47# A3 a_911_47# VNB abnmos
X63 a_1269_47# A3 a_911_47# VNB abnmos
X64 Y B1 VGND VNB abnmos
X65 Y B1 VGND VNB abnmos
X66 a_27_297# B1 Y VPB abpmos
X67 a_27_297# B1 Y VPB abpmos
X68 a_27_297# B1 Y VPB abpmos
X69 a_27_297# A1 VPWR VPB abpmos
X70 a_27_297# A1 VPWR VPB abpmos
X71 a_27_297# A1 VPWR VPB abpmos
X72 Y B1 VGND VNB abnmos
X73 Y B1 VGND VNB abnmos
X74 a_1269_47# A4 VGND VNB abnmos
X75 a_1269_47# A4 VGND VNB abnmos
X76 a_27_297# A2 VPWR VPB abpmos
X77 a_27_297# A2 VPWR VPB abpmos
X78 a_27_297# A2 VPWR VPB abpmos
X79 a_27_297# B1 Y VPB abpmos
X80 a_27_297# B1 Y VPB abpmos
X81 a_27_297# B1 Y VPB abpmos
X82 Y B1 a_27_297# VPB abpmos
X83 Y B1 a_27_297# VPB abpmos
X84 Y B1 a_27_297# VPB abpmos
X85 a_27_297# A2 VPWR VPB abpmos
X86 a_27_297# A2 VPWR VPB abpmos
X87 a_27_297# A2 VPWR VPB abpmos
X88 a_1269_47# A3 a_911_47# VNB abnmos
X89 a_1269_47# A3 a_911_47# VNB abnmos
X90 a_1269_47# A4 VGND VNB abnmos
X91 a_1269_47# A4 VGND VNB abnmos
X92 Y B1 a_27_297# VPB abpmos
X93 Y B1 a_27_297# VPB abpmos
X94 Y B1 a_27_297# VPB abpmos
X95 a_27_297# A2 VPWR VPB abpmos
X96 a_27_297# A2 VPWR VPB abpmos
X97 a_27_297# A2 VPWR VPB abpmos
X98 a_493_47# A2 a_911_47# VNB abnmos
X99 a_493_47# A2 a_911_47# VNB abnmos
.ends A41OID4B
