* A211OD1 : abstract conversion of sky130_fd_sc_hd__a211o_1
* 25 abstract devices (width -> parallel min-width fingers)
.subckt A211OD1 A1 A2 B1 C1 VGND VPWR X
XA211OD1B A1 A2 B1 C1 VGND VGND VPWR VPWR X A211OD1B
.ends A211OD1

.subckt A211OD1B A1 A2 B1 C1 VGND VNB VPB VPWR X
X0 a_300_47# A2 VGND VNB abnmos
X1 a_300_47# A2 VGND VNB abnmos
X2 X a_80_21# VPWR VPB abpmos
X3 X a_80_21# VPWR VPB abpmos
X4 X a_80_21# VPWR VPB abpmos
X5 X a_80_21# VGND VNB abnmos
X6 X a_80_21# VGND VNB abnmos
X7 a_300_47# A1 a_80_21# VNB abnmos
X8 a_300_47# A1 a_80_21# VNB abnmos
X9 a_80_21# B1 VGND VNB abnmos
X10 a_80_21# B1 VGND VNB abnmos
X11 a_472_297# C1 a_80_21# VPB abpmos
X12 a_472_297# C1 a_80_21# VPB abpmos
X13 a_472_297# C1 a_80_21# VPB abpmos
X14 a_80_21# C1 VGND VNB abnmos
X15 a_80_21# C1 VGND VNB abnmos
X16 a_217_297# A1 VPWR VPB abpmos
X17 a_217_297# A1 VPWR VPB abpmos
X18 a_217_297# A1 VPWR VPB abpmos
X19 a_217_297# A2 VPWR VPB abpmos
X20 a_217_297# A2 VPWR VPB abpmos
X21 a_217_297# A2 VPWR VPB abpmos
X22 a_217_297# B1 a_472_297# VPB abpmos
X23 a_217_297# B1 a_472_297# VPB abpmos
X24 a_217_297# B1 a_472_297# VPB abpmos
.ends A211OD1B
