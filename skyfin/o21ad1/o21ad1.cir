* O21AD1 : abstract conversion of sky130_fd_sc_hd__o21a_1
* 20 abstract devices (width -> parallel min-width fingers)
.subckt O21AD1 A1 A2 B1 VGND VPWR X
XO21AD1B A1 A2 B1 VGND VGND VPWR VPWR X O21AD1B
.ends O21AD1

.subckt O21AD1B A1 A2 B1 VGND VNB VPB VPWR X
X0 a_382_297# A1 VPWR VPB abpmos
X1 a_382_297# A1 VPWR VPB abpmos
X2 a_382_297# A1 VPWR VPB abpmos
X3 a_297_47# A1 VGND VNB abnmos
X4 a_297_47# A1 VGND VNB abnmos
X5 a_79_21# B1 a_297_47# VNB abnmos
X6 a_79_21# B1 a_297_47# VNB abnmos
X7 X a_79_21# VPWR VPB abpmos
X8 X a_79_21# VPWR VPB abpmos
X9 X a_79_21# VPWR VPB abpmos
X10 a_297_47# A2 VGND VNB abnmos
X11 a_297_47# A2 VGND VNB abnmos
X12 a_79_21# A2 a_382_297# VPB abpmos
X13 a_79_21# A2 a_382_297# VPB abpmos
X14 a_79_21# A2 a_382_297# VPB abpmos
X15 a_79_21# B1 VPWR VPB abpmos
X16 a_79_21# B1 VPWR VPB abpmos
X17 a_79_21# B1 VPWR VPB abpmos
X18 X a_79_21# VGND VNB abnmos
X19 X a_79_21# VGND VNB abnmos
.ends O21AD1B
