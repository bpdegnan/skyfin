* O311AID0 : abstract conversion of sky130_fd_sc_hd__o311ai_0
* 15 abstract devices (width -> parallel min-width fingers)
.subckt O311AID0 A1 A2 A3 B1 C1 VGND VPWR Y
XO311AID0B A1 A2 A3 B1 C1 VGND VGND VPWR VPWR Y O311AID0B
.ends O311AID0

.subckt O311AID0B A1 A2 A3 B1 C1 VGND VNB VPB VPWR Y
X0 a_138_47# B1 a_458_47# VNB abnmos
X1 a_138_369# A1 VPWR VPB abpmos
X2 a_138_369# A1 VPWR VPB abpmos
X3 a_138_47# A3 VGND VNB abnmos
X4 a_138_47# A1 VGND VNB abnmos
X5 a_458_47# C1 Y VNB abnmos
X6 a_138_47# A2 VGND VNB abnmos
X7 Y B1 VPWR VPB abpmos
X8 Y B1 VPWR VPB abpmos
X9 a_222_369# A3 Y VPB abpmos
X10 a_222_369# A3 Y VPB abpmos
X11 Y C1 VPWR VPB abpmos
X12 Y C1 VPWR VPB abpmos
X13 a_138_369# A2 a_222_369# VPB abpmos
X14 a_138_369# A2 a_222_369# VPB abpmos
.ends O311AID0B
