* MUX2ID2 : abstract conversion of sky130_fd_sc_hd__mux2i_2
* 45 abstract devices (width -> parallel min-width fingers)
.subckt MUX2ID2 A0 A1 S VGND VPWR Y
XMUX2ID2B A0 A1 S VGND VGND VPWR VPWR Y MUX2ID2B
.ends MUX2ID2

.subckt MUX2ID2B A0 A1 S VGND VNB VPB VPWR Y
X0 a_361_47# a_27_47# VGND VNB abnmos
X1 a_361_47# a_27_47# VGND VNB abnmos
X2 a_193_47# A1 Y VNB abnmos
X3 a_193_47# A1 Y VNB abnmos
X4 Y A0 a_361_47# VNB abnmos
X5 Y A0 a_361_47# VNB abnmos
X6 a_361_47# a_27_47# VGND VNB abnmos
X7 a_361_47# a_27_47# VGND VNB abnmos
X8 Y A1 a_361_297# VPB abpmos
X9 Y A1 a_361_297# VPB abpmos
X10 Y A1 a_361_297# VPB abpmos
X11 Y A0 a_193_297# VPB abpmos
X12 Y A0 a_193_297# VPB abpmos
X13 Y A0 a_193_297# VPB abpmos
X14 a_361_47# A0 Y VNB abnmos
X15 a_361_47# A0 Y VNB abnmos
X16 a_361_297# A1 Y VPB abpmos
X17 a_361_297# A1 Y VPB abpmos
X18 a_361_297# A1 Y VPB abpmos
X19 a_193_47# S VGND VNB abnmos
X20 a_193_47# S VGND VNB abnmos
X21 a_193_47# S VGND VNB abnmos
X22 a_193_47# S VGND VNB abnmos
X23 a_193_297# S VPWR VPB abpmos
X24 a_193_297# S VPWR VPB abpmos
X25 a_193_297# S VPWR VPB abpmos
X26 a_193_297# A0 Y VPB abpmos
X27 a_193_297# A0 Y VPB abpmos
X28 a_193_297# A0 Y VPB abpmos
X29 a_27_47# S VGND VNB abnmos
X30 a_27_47# S VGND VNB abnmos
X31 Y A1 a_193_47# VNB abnmos
X32 Y A1 a_193_47# VNB abnmos
X33 a_361_297# a_27_47# VPWR VPB abpmos
X34 a_361_297# a_27_47# VPWR VPB abpmos
X35 a_361_297# a_27_47# VPWR VPB abpmos
X36 a_27_47# S VPWR VPB abpmos
X37 a_27_47# S VPWR VPB abpmos
X38 a_27_47# S VPWR VPB abpmos
X39 a_193_297# S VPWR VPB abpmos
X40 a_193_297# S VPWR VPB abpmos
X41 a_193_297# S VPWR VPB abpmos
X42 a_361_297# a_27_47# VPWR VPB abpmos
X43 a_361_297# a_27_47# VPWR VPB abpmos
X44 a_361_297# a_27_47# VPWR VPB abpmos
.ends MUX2ID2B
