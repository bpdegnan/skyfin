* A311OD2 : abstract conversion of sky130_fd_sc_hd__a311o_2
* 35 abstract devices (width -> parallel min-width fingers)
.subckt A311OD2 A1 A2 A3 B1 C1 VGND VPWR X
XA311OD2B A1 A2 A3 B1 C1 VGND VGND VPWR VPWR X A311OD2B
.ends A311OD2

.subckt A311OD2B A1 A2 A3 B1 C1 VGND VNB VPB VPWR X
X0 a_319_297# A2 VPWR VPB abpmos
X1 a_319_297# A2 VPWR VPB abpmos
X2 a_319_297# A2 VPWR VPB abpmos
X3 a_79_21# B1 VGND VNB abnmos
X4 a_79_21# B1 VGND VNB abnmos
X5 a_319_47# A3 VGND VNB abnmos
X6 a_319_47# A3 VGND VNB abnmos
X7 a_319_297# B1 a_635_297# VPB abpmos
X8 a_319_297# B1 a_635_297# VPB abpmos
X9 a_319_297# B1 a_635_297# VPB abpmos
X10 a_319_47# A2 a_417_47# VNB abnmos
X11 a_319_47# A2 a_417_47# VNB abnmos
X12 a_635_297# C1 a_79_21# VPB abpmos
X13 a_635_297# C1 a_79_21# VPB abpmos
X14 a_635_297# C1 a_79_21# VPB abpmos
X15 X a_79_21# VGND VNB abnmos
X16 X a_79_21# VGND VNB abnmos
X17 X a_79_21# VGND VNB abnmos
X18 X a_79_21# VGND VNB abnmos
X19 a_417_47# A1 a_79_21# VNB abnmos
X20 a_417_47# A1 a_79_21# VNB abnmos
X21 a_319_297# A1 VPWR VPB abpmos
X22 a_319_297# A1 VPWR VPB abpmos
X23 a_319_297# A1 VPWR VPB abpmos
X24 X a_79_21# VPWR VPB abpmos
X25 X a_79_21# VPWR VPB abpmos
X26 X a_79_21# VPWR VPB abpmos
X27 X a_79_21# VPWR VPB abpmos
X28 X a_79_21# VPWR VPB abpmos
X29 X a_79_21# VPWR VPB abpmos
X30 a_79_21# C1 VGND VNB abnmos
X31 a_79_21# C1 VGND VNB abnmos
X32 a_319_297# A3 VPWR VPB abpmos
X33 a_319_297# A3 VPWR VPB abpmos
X34 a_319_297# A3 VPWR VPB abpmos
.ends A311OD2B
