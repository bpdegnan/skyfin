* O2111AID2 : abstract conversion of sky130_fd_sc_hd__o2111ai_2
* 50 abstract devices (width -> parallel min-width fingers)
.subckt O2111AID2 A1 A2 B1 C1 D1 VGND VPWR Y
XO2111AID2B A1 A2 B1 C1 D1 VGND VGND VPWR VPWR Y O2111AID2B
.ends O2111AID2

.subckt O2111AID2B A1 A2 B1 C1 D1 VGND VNB VPB VPWR Y
X0 Y A2 a_664_297# VPB abpmos
X1 Y A2 a_664_297# VPB abpmos
X2 Y A2 a_664_297# VPB abpmos
X3 a_664_297# A2 Y VPB abpmos
X4 a_664_297# A2 Y VPB abpmos
X5 a_664_297# A2 Y VPB abpmos
X6 a_664_297# A1 VPWR VPB abpmos
X7 a_664_297# A1 VPWR VPB abpmos
X8 a_664_297# A1 VPWR VPB abpmos
X9 a_497_47# B1 a_298_47# VNB abnmos
X10 a_497_47# B1 a_298_47# VNB abnmos
X11 Y D1 VPWR VPB abpmos
X12 Y D1 VPWR VPB abpmos
X13 Y D1 VPWR VPB abpmos
X14 a_497_47# A1 VGND VNB abnmos
X15 a_497_47# A1 VGND VNB abnmos
X16 a_27_47# D1 Y VNB abnmos
X17 a_27_47# D1 Y VNB abnmos
X18 a_497_47# A1 VGND VNB abnmos
X19 a_497_47# A1 VGND VNB abnmos
X20 Y C1 VPWR VPB abpmos
X21 Y C1 VPWR VPB abpmos
X22 Y C1 VPWR VPB abpmos
X23 Y D1 VPWR VPB abpmos
X24 Y D1 VPWR VPB abpmos
X25 Y D1 VPWR VPB abpmos
X26 a_298_47# B1 a_497_47# VNB abnmos
X27 a_298_47# B1 a_497_47# VNB abnmos
X28 a_497_47# A2 VGND VNB abnmos
X29 a_497_47# A2 VGND VNB abnmos
X30 Y C1 VPWR VPB abpmos
X31 Y C1 VPWR VPB abpmos
X32 Y C1 VPWR VPB abpmos
X33 Y D1 a_27_47# VNB abnmos
X34 Y D1 a_27_47# VNB abnmos
X35 a_497_47# A2 VGND VNB abnmos
X36 a_497_47# A2 VGND VNB abnmos
X37 Y B1 VPWR VPB abpmos
X38 Y B1 VPWR VPB abpmos
X39 Y B1 VPWR VPB abpmos
X40 Y B1 VPWR VPB abpmos
X41 Y B1 VPWR VPB abpmos
X42 Y B1 VPWR VPB abpmos
X43 a_664_297# A1 VPWR VPB abpmos
X44 a_664_297# A1 VPWR VPB abpmos
X45 a_664_297# A1 VPWR VPB abpmos
X46 a_27_47# C1 a_298_47# VNB abnmos
X47 a_27_47# C1 a_298_47# VNB abnmos
X48 a_298_47# C1 a_27_47# VNB abnmos
X49 a_298_47# C1 a_27_47# VNB abnmos
.ends O2111AID2B
