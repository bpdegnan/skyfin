* A32OID4 : abstract conversion of sky130_fd_sc_hd__a32oi_4
* 100 abstract devices (width -> parallel min-width fingers)
.subckt A32OID4 A1 A2 A3 B1 B2 VGND VPWR Y
XA32OID4B A1 A2 A3 B1 B2 VGND VGND VPWR VPWR Y A32OID4B
.ends A32OID4

.subckt A32OID4B A1 A2 A3 B1 B2 VGND VNB VPB VPWR Y
X0 a_803_47# A1 Y VNB abnmos
X1 a_803_47# A1 Y VNB abnmos
X2 a_27_47# B1 Y VNB abnmos
X3 a_27_47# B1 Y VNB abnmos
X4 a_27_297# A2 VPWR VPB abpmos
X5 a_27_297# A2 VPWR VPB abpmos
X6 a_27_297# A2 VPWR VPB abpmos
X7 a_27_47# B1 Y VNB abnmos
X8 a_27_47# B1 Y VNB abnmos
X9 a_803_47# A1 Y VNB abnmos
X10 a_803_47# A1 Y VNB abnmos
X11 Y B1 a_27_297# VPB abpmos
X12 Y B1 a_27_297# VPB abpmos
X13 Y B1 a_27_297# VPB abpmos
X14 Y B1 a_27_297# VPB abpmos
X15 Y B1 a_27_297# VPB abpmos
X16 Y B1 a_27_297# VPB abpmos
X17 a_27_297# A2 VPWR VPB abpmos
X18 a_27_297# A2 VPWR VPB abpmos
X19 a_27_297# A2 VPWR VPB abpmos
X20 a_27_47# B2 VGND VNB abnmos
X21 a_27_47# B2 VGND VNB abnmos
X22 a_1249_47# A3 VGND VNB abnmos
X23 a_1249_47# A3 VGND VNB abnmos
X24 a_27_297# B1 Y VPB abpmos
X25 a_27_297# B1 Y VPB abpmos
X26 a_27_297# B1 Y VPB abpmos
X27 Y B1 a_27_47# VNB abnmos
X28 Y B1 a_27_47# VNB abnmos
X29 a_27_297# A1 VPWR VPB abpmos
X30 a_27_297# A1 VPWR VPB abpmos
X31 a_27_297# A1 VPWR VPB abpmos
X32 a_27_297# A1 VPWR VPB abpmos
X33 a_27_297# A1 VPWR VPB abpmos
X34 a_27_297# A1 VPWR VPB abpmos
X35 a_1249_47# A2 a_803_47# VNB abnmos
X36 a_1249_47# A2 a_803_47# VNB abnmos
X37 a_1249_47# A3 VGND VNB abnmos
X38 a_1249_47# A3 VGND VNB abnmos
X39 a_27_297# A3 VPWR VPB abpmos
X40 a_27_297# A3 VPWR VPB abpmos
X41 a_27_297# A3 VPWR VPB abpmos
X42 a_1249_47# A2 a_803_47# VNB abnmos
X43 a_1249_47# A2 a_803_47# VNB abnmos
X44 a_27_297# A2 VPWR VPB abpmos
X45 a_27_297# A2 VPWR VPB abpmos
X46 a_27_297# A2 VPWR VPB abpmos
X47 a_27_297# A1 VPWR VPB abpmos
X48 a_27_297# A1 VPWR VPB abpmos
X49 a_27_297# A1 VPWR VPB abpmos
X50 a_27_297# A3 VPWR VPB abpmos
X51 a_27_297# A3 VPWR VPB abpmos
X52 a_27_297# A3 VPWR VPB abpmos
X53 a_27_47# B2 VGND VNB abnmos
X54 a_27_47# B2 VGND VNB abnmos
X55 a_27_297# A1 VPWR VPB abpmos
X56 a_27_297# A1 VPWR VPB abpmos
X57 a_27_297# A1 VPWR VPB abpmos
X58 a_27_297# A2 VPWR VPB abpmos
X59 a_27_297# A2 VPWR VPB abpmos
X60 a_27_297# A2 VPWR VPB abpmos
X61 a_27_297# A3 VPWR VPB abpmos
X62 a_27_297# A3 VPWR VPB abpmos
X63 a_27_297# A3 VPWR VPB abpmos
X64 a_27_297# A3 VPWR VPB abpmos
X65 a_27_297# A3 VPWR VPB abpmos
X66 a_27_297# A3 VPWR VPB abpmos
X67 a_27_47# B2 VGND VNB abnmos
X68 a_27_47# B2 VGND VNB abnmos
X69 a_27_297# B2 Y VPB abpmos
X70 a_27_297# B2 Y VPB abpmos
X71 a_27_297# B2 Y VPB abpmos
X72 a_27_47# B2 VGND VNB abnmos
X73 a_27_47# B2 VGND VNB abnmos
X74 a_1249_47# A3 VGND VNB abnmos
X75 a_1249_47# A3 VGND VNB abnmos
X76 a_27_297# B1 Y VPB abpmos
X77 a_27_297# B1 Y VPB abpmos
X78 a_27_297# B1 Y VPB abpmos
X79 a_803_47# A2 a_1249_47# VNB abnmos
X80 a_803_47# A2 a_1249_47# VNB abnmos
X81 a_27_297# B2 Y VPB abpmos
X82 a_27_297# B2 Y VPB abpmos
X83 a_27_297# B2 Y VPB abpmos
X84 a_803_47# A2 a_1249_47# VNB abnmos
X85 a_803_47# A2 a_1249_47# VNB abnmos
X86 Y B2 a_27_297# VPB abpmos
X87 Y B2 a_27_297# VPB abpmos
X88 Y B2 a_27_297# VPB abpmos
X89 Y A1 a_803_47# VNB abnmos
X90 Y A1 a_803_47# VNB abnmos
X91 Y B1 a_27_47# VNB abnmos
X92 Y B1 a_27_47# VNB abnmos
X93 Y B2 a_27_297# VPB abpmos
X94 Y B2 a_27_297# VPB abpmos
X95 Y B2 a_27_297# VPB abpmos
X96 a_1249_47# A3 VGND VNB abnmos
X97 a_1249_47# A3 VGND VNB abnmos
X98 Y A1 a_803_47# VNB abnmos
X99 Y A1 a_803_47# VNB abnmos
.ends A32OID4B
