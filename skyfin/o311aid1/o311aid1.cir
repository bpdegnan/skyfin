* O311AID1 : abstract conversion of sky130_fd_sc_hd__o311ai_1
* 25 abstract devices (width -> parallel min-width fingers)
.subckt O311AID1 A1 A2 A3 B1 C1 VGND VPWR Y
XO311AID1B A1 A2 A3 B1 C1 VGND VGND VPWR VPWR Y O311AID1B
.ends O311AID1

.subckt O311AID1B A1 A2 A3 B1 C1 VGND VNB VPB VPWR Y
X0 Y C1 VPWR VPB abpmos
X1 Y C1 VPWR VPB abpmos
X2 Y C1 VPWR VPB abpmos
X3 a_138_47# B1 a_458_47# VNB abnmos
X4 a_138_47# B1 a_458_47# VNB abnmos
X5 a_222_297# A3 Y VPB abpmos
X6 a_222_297# A3 Y VPB abpmos
X7 a_222_297# A3 Y VPB abpmos
X8 a_138_297# A2 a_222_297# VPB abpmos
X9 a_138_297# A2 a_222_297# VPB abpmos
X10 a_138_297# A2 a_222_297# VPB abpmos
X11 a_138_47# A3 VGND VNB abnmos
X12 a_138_47# A3 VGND VNB abnmos
X13 a_138_47# A1 VGND VNB abnmos
X14 a_138_47# A1 VGND VNB abnmos
X15 a_458_47# C1 Y VNB abnmos
X16 a_458_47# C1 Y VNB abnmos
X17 a_138_47# A2 VGND VNB abnmos
X18 a_138_47# A2 VGND VNB abnmos
X19 a_138_297# A1 VPWR VPB abpmos
X20 a_138_297# A1 VPWR VPB abpmos
X21 a_138_297# A1 VPWR VPB abpmos
X22 Y B1 VPWR VPB abpmos
X23 Y B1 VPWR VPB abpmos
X24 Y B1 VPWR VPB abpmos
.ends O311AID1B
