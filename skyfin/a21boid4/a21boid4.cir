* A21BOID4 : abstract conversion of sky130_fd_sc_hd__a21boi_4
* 65 abstract devices (width -> parallel min-width fingers)
.subckt A21BOID4 A1 A2 B1_N VGND VPWR Y
XA21BOID4B A1 A2 B1_N VGND VGND VPWR VPWR Y A21BOID4B
.ends A21BOID4

.subckt A21BOID4B A1 A2 B1_N VGND VNB VPB VPWR Y
X0 a_223_297# a_27_47# Y VPB abpmos
X1 a_223_297# a_27_47# Y VPB abpmos
X2 a_223_297# a_27_47# Y VPB abpmos
X3 a_223_297# A2 VPWR VPB abpmos
X4 a_223_297# A2 VPWR VPB abpmos
X5 a_223_297# A2 VPWR VPB abpmos
X6 a_658_47# A2 VGND VNB abnmos
X7 a_658_47# A2 VGND VNB abnmos
X8 a_223_297# A2 VPWR VPB abpmos
X9 a_223_297# A2 VPWR VPB abpmos
X10 a_223_297# A2 VPWR VPB abpmos
X11 a_658_47# A2 VGND VNB abnmos
X12 a_658_47# A2 VGND VNB abnmos
X13 a_658_47# A2 VGND VNB abnmos
X14 a_658_47# A2 VGND VNB abnmos
X15 a_223_297# A1 VPWR VPB abpmos
X16 a_223_297# A1 VPWR VPB abpmos
X17 a_223_297# A1 VPWR VPB abpmos
X18 a_658_47# A1 Y VNB abnmos
X19 a_658_47# A1 Y VNB abnmos
X20 Y a_27_47# VGND VNB abnmos
X21 Y a_27_47# VGND VNB abnmos
X22 Y A1 a_658_47# VNB abnmos
X23 Y A1 a_658_47# VNB abnmos
X24 a_223_297# a_27_47# Y VPB abpmos
X25 a_223_297# a_27_47# Y VPB abpmos
X26 a_223_297# a_27_47# Y VPB abpmos
X27 Y a_27_47# VGND VNB abnmos
X28 Y a_27_47# VGND VNB abnmos
X29 Y a_27_47# a_223_297# VPB abpmos
X30 Y a_27_47# a_223_297# VPB abpmos
X31 Y a_27_47# a_223_297# VPB abpmos
X32 a_658_47# A2 VGND VNB abnmos
X33 a_658_47# A2 VGND VNB abnmos
X34 a_223_297# A2 VPWR VPB abpmos
X35 a_223_297# A2 VPWR VPB abpmos
X36 a_223_297# A2 VPWR VPB abpmos
X37 a_658_47# A1 Y VNB abnmos
X38 a_658_47# A1 Y VNB abnmos
X39 a_223_297# A1 VPWR VPB abpmos
X40 a_223_297# A1 VPWR VPB abpmos
X41 a_223_297# A1 VPWR VPB abpmos
X42 a_223_297# A1 VPWR VPB abpmos
X43 a_223_297# A1 VPWR VPB abpmos
X44 a_223_297# A1 VPWR VPB abpmos
X45 Y a_27_47# VGND VNB abnmos
X46 Y a_27_47# VGND VNB abnmos
X47 Y A1 a_658_47# VNB abnmos
X48 Y A1 a_658_47# VNB abnmos
X49 a_27_47# B1_N VPWR VPB abpmos
X50 a_27_47# B1_N VPWR VPB abpmos
X51 a_27_47# B1_N VPWR VPB abpmos
X52 Y a_27_47# VGND VNB abnmos
X53 Y a_27_47# VGND VNB abnmos
X54 Y a_27_47# a_223_297# VPB abpmos
X55 Y a_27_47# a_223_297# VPB abpmos
X56 Y a_27_47# a_223_297# VPB abpmos
X57 a_27_47# B1_N VGND VNB abnmos
X58 a_27_47# B1_N VGND VNB abnmos
X59 a_223_297# A2 VPWR VPB abpmos
X60 a_223_297# A2 VPWR VPB abpmos
X61 a_223_297# A2 VPWR VPB abpmos
X62 a_223_297# A1 VPWR VPB abpmos
X63 a_223_297# A1 VPWR VPB abpmos
X64 a_223_297# A1 VPWR VPB abpmos
.ends A21BOID4B
