* O32AD2 : abstract conversion of sky130_fd_sc_hd__o32a_2
* 35 abstract devices (width -> parallel min-width fingers)
.subckt O32AD2 A1 A2 A3 B1 B2 VGND VPWR X
XO32AD2B A1 A2 A3 B1 B2 VGND VGND VPWR VPWR X O32AD2B
.ends O32AD2

.subckt O32AD2B A1 A2 A3 B1 B2 VGND VNB VPB VPWR X
X0 a_429_297# A3 a_79_21# VPB abpmos
X1 a_429_297# A3 a_79_21# VPB abpmos
X2 a_429_297# A3 a_79_21# VPB abpmos
X3 a_345_47# B2 a_79_21# VNB abnmos
X4 a_345_47# B2 a_79_21# VNB abnmos
X5 a_79_21# B1 a_345_47# VNB abnmos
X6 a_79_21# B1 a_345_47# VNB abnmos
X7 a_79_21# B2 a_629_297# VPB abpmos
X8 a_79_21# B2 a_629_297# VPB abpmos
X9 a_79_21# B2 a_629_297# VPB abpmos
X10 a_345_47# A1 VGND VNB abnmos
X11 a_345_47# A1 VGND VNB abnmos
X12 a_345_297# A1 VPWR VPB abpmos
X13 a_345_297# A1 VPWR VPB abpmos
X14 a_345_297# A1 VPWR VPB abpmos
X15 a_629_297# B1 VPWR VPB abpmos
X16 a_629_297# B1 VPWR VPB abpmos
X17 a_629_297# B1 VPWR VPB abpmos
X18 X a_79_21# VGND VNB abnmos
X19 X a_79_21# VGND VNB abnmos
X20 a_345_47# A2 VGND VNB abnmos
X21 a_345_47# A2 VGND VNB abnmos
X22 X a_79_21# VGND VNB abnmos
X23 X a_79_21# VGND VNB abnmos
X24 a_345_47# A3 VGND VNB abnmos
X25 a_345_47# A3 VGND VNB abnmos
X26 X a_79_21# VPWR VPB abpmos
X27 X a_79_21# VPWR VPB abpmos
X28 X a_79_21# VPWR VPB abpmos
X29 X a_79_21# VPWR VPB abpmos
X30 X a_79_21# VPWR VPB abpmos
X31 X a_79_21# VPWR VPB abpmos
X32 a_345_297# A2 a_429_297# VPB abpmos
X33 a_345_297# A2 a_429_297# VPB abpmos
X34 a_345_297# A2 a_429_297# VPB abpmos
.ends O32AD2B
