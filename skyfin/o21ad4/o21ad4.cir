* O21AD4 : abstract conversion of sky130_fd_sc_hd__o21a_4
* 50 abstract devices (width -> parallel min-width fingers)
.subckt O21AD4 A1 A2 B1 VGND VPWR X
XO21AD4B A1 A2 B1 VGND VGND VPWR VPWR X O21AD4B
.ends O21AD4

.subckt O21AD4B A1 A2 B1 VGND VNB VPB VPWR X
X0 a_80_21# A2 a_934_297# VPB abpmos
X1 a_80_21# A2 a_934_297# VPB abpmos
X2 a_80_21# A2 a_934_297# VPB abpmos
X3 X a_80_21# VGND VNB abnmos
X4 X a_80_21# VGND VNB abnmos
X5 X a_80_21# VGND VNB abnmos
X6 X a_80_21# VGND VNB abnmos
X7 X a_80_21# VPWR VPB abpmos
X8 X a_80_21# VPWR VPB abpmos
X9 X a_80_21# VPWR VPB abpmos
X10 a_475_47# A1 VGND VNB abnmos
X11 a_475_47# A1 VGND VNB abnmos
X12 X a_80_21# VPWR VPB abpmos
X13 X a_80_21# VPWR VPB abpmos
X14 X a_80_21# VPWR VPB abpmos
X15 X a_80_21# VPWR VPB abpmos
X16 X a_80_21# VPWR VPB abpmos
X17 X a_80_21# VPWR VPB abpmos
X18 a_475_47# B1 a_80_21# VNB abnmos
X19 a_475_47# B1 a_80_21# VNB abnmos
X20 a_80_21# B1 a_475_47# VNB abnmos
X21 a_80_21# B1 a_475_47# VNB abnmos
X22 a_80_21# B1 VPWR VPB abpmos
X23 a_80_21# B1 VPWR VPB abpmos
X24 a_80_21# B1 VPWR VPB abpmos
X25 X a_80_21# VGND VNB abnmos
X26 X a_80_21# VGND VNB abnmos
X27 a_475_47# A1 VGND VNB abnmos
X28 a_475_47# A1 VGND VNB abnmos
X29 a_80_21# B1 VPWR VPB abpmos
X30 a_80_21# B1 VPWR VPB abpmos
X31 a_80_21# B1 VPWR VPB abpmos
X32 a_762_297# A2 a_80_21# VPB abpmos
X33 a_762_297# A2 a_80_21# VPB abpmos
X34 a_762_297# A2 a_80_21# VPB abpmos
X35 X a_80_21# VPWR VPB abpmos
X36 X a_80_21# VPWR VPB abpmos
X37 X a_80_21# VPWR VPB abpmos
X38 a_762_297# A1 VPWR VPB abpmos
X39 a_762_297# A1 VPWR VPB abpmos
X40 a_762_297# A1 VPWR VPB abpmos
X41 a_934_297# A1 VPWR VPB abpmos
X42 a_934_297# A1 VPWR VPB abpmos
X43 a_934_297# A1 VPWR VPB abpmos
X44 X a_80_21# VGND VNB abnmos
X45 X a_80_21# VGND VNB abnmos
X46 a_475_47# A2 VGND VNB abnmos
X47 a_475_47# A2 VGND VNB abnmos
X48 a_475_47# A2 VGND VNB abnmos
X49 a_475_47# A2 VGND VNB abnmos
.ends O21AD4B
