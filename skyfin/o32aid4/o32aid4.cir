* O32AID4 : abstract conversion of sky130_fd_sc_hd__o32ai_4
* 100 abstract devices (width -> parallel min-width fingers)
.subckt O32AID4 A1 A2 A3 B1 B2 VGND VPWR Y
XO32AID4B A1 A2 A3 B1 B2 VGND VGND VPWR VPWR Y O32AID4B
.ends O32AID4

.subckt O32AID4B A1 A2 A3 B1 B2 VGND VNB VPB VPWR Y
X0 a_27_47# A2 VGND VNB abnmos
X1 a_27_47# A2 VGND VNB abnmos
X2 Y A3 a_806_297# VPB abpmos
X3 Y A3 a_806_297# VPB abpmos
X4 Y A3 a_806_297# VPB abpmos
X5 a_1224_297# A2 a_806_297# VPB abpmos
X6 a_1224_297# A2 a_806_297# VPB abpmos
X7 a_1224_297# A2 a_806_297# VPB abpmos
X8 a_27_297# B1 VPWR VPB abpmos
X9 a_27_297# B1 VPWR VPB abpmos
X10 a_27_297# B1 VPWR VPB abpmos
X11 a_1224_297# A1 VPWR VPB abpmos
X12 a_1224_297# A1 VPWR VPB abpmos
X13 a_1224_297# A1 VPWR VPB abpmos
X14 a_27_47# B1 Y VNB abnmos
X15 a_27_47# B1 Y VNB abnmos
X16 a_27_47# A3 VGND VNB abnmos
X17 a_27_47# A3 VGND VNB abnmos
X18 a_1224_297# A2 a_806_297# VPB abpmos
X19 a_1224_297# A2 a_806_297# VPB abpmos
X20 a_1224_297# A2 a_806_297# VPB abpmos
X21 a_27_47# A2 VGND VNB abnmos
X22 a_27_47# A2 VGND VNB abnmos
X23 a_27_47# A1 VGND VNB abnmos
X24 a_27_47# A1 VGND VNB abnmos
X25 a_27_47# B1 Y VNB abnmos
X26 a_27_47# B1 Y VNB abnmos
X27 a_806_297# A2 a_1224_297# VPB abpmos
X28 a_806_297# A2 a_1224_297# VPB abpmos
X29 a_806_297# A2 a_1224_297# VPB abpmos
X30 Y B2 a_27_47# VNB abnmos
X31 Y B2 a_27_47# VNB abnmos
X32 a_806_297# A2 a_1224_297# VPB abpmos
X33 a_806_297# A2 a_1224_297# VPB abpmos
X34 a_806_297# A2 a_1224_297# VPB abpmos
X35 a_27_47# A3 VGND VNB abnmos
X36 a_27_47# A3 VGND VNB abnmos
X37 a_27_297# B1 VPWR VPB abpmos
X38 a_27_297# B1 VPWR VPB abpmos
X39 a_27_297# B1 VPWR VPB abpmos
X40 a_27_47# A3 VGND VNB abnmos
X41 a_27_47# A3 VGND VNB abnmos
X42 a_27_47# A1 VGND VNB abnmos
X43 a_27_47# A1 VGND VNB abnmos
X44 a_27_47# A2 VGND VNB abnmos
X45 a_27_47# A2 VGND VNB abnmos
X46 a_27_47# B2 Y VNB abnmos
X47 a_27_47# B2 Y VNB abnmos
X48 a_1224_297# A1 VPWR VPB abpmos
X49 a_1224_297# A1 VPWR VPB abpmos
X50 a_1224_297# A1 VPWR VPB abpmos
X51 a_27_47# A3 VGND VNB abnmos
X52 a_27_47# A3 VGND VNB abnmos
X53 a_27_297# B1 VPWR VPB abpmos
X54 a_27_297# B1 VPWR VPB abpmos
X55 a_27_297# B1 VPWR VPB abpmos
X56 a_27_47# A2 VGND VNB abnmos
X57 a_27_47# A2 VGND VNB abnmos
X58 a_27_47# A1 VGND VNB abnmos
X59 a_27_47# A1 VGND VNB abnmos
X60 a_806_297# A3 Y VPB abpmos
X61 a_806_297# A3 Y VPB abpmos
X62 a_806_297# A3 Y VPB abpmos
X63 a_1224_297# A1 VPWR VPB abpmos
X64 a_1224_297# A1 VPWR VPB abpmos
X65 a_1224_297# A1 VPWR VPB abpmos
X66 Y B2 a_27_47# VNB abnmos
X67 Y B2 a_27_47# VNB abnmos
X68 a_27_297# B2 Y VPB abpmos
X69 a_27_297# B2 Y VPB abpmos
X70 a_27_297# B2 Y VPB abpmos
X71 a_27_47# B2 Y VNB abnmos
X72 a_27_47# B2 Y VNB abnmos
X73 a_1224_297# A1 VPWR VPB abpmos
X74 a_1224_297# A1 VPWR VPB abpmos
X75 a_1224_297# A1 VPWR VPB abpmos
X76 Y B1 a_27_47# VNB abnmos
X77 Y B1 a_27_47# VNB abnmos
X78 Y B1 a_27_47# VNB abnmos
X79 Y B1 a_27_47# VNB abnmos
X80 a_27_297# B2 Y VPB abpmos
X81 a_27_297# B2 Y VPB abpmos
X82 a_27_297# B2 Y VPB abpmos
X83 Y A3 a_806_297# VPB abpmos
X84 Y A3 a_806_297# VPB abpmos
X85 Y A3 a_806_297# VPB abpmos
X86 Y B2 a_27_297# VPB abpmos
X87 Y B2 a_27_297# VPB abpmos
X88 Y B2 a_27_297# VPB abpmos
X89 Y B2 a_27_297# VPB abpmos
X90 Y B2 a_27_297# VPB abpmos
X91 Y B2 a_27_297# VPB abpmos
X92 a_27_297# B1 VPWR VPB abpmos
X93 a_27_297# B1 VPWR VPB abpmos
X94 a_27_297# B1 VPWR VPB abpmos
X95 a_806_297# A3 Y VPB abpmos
X96 a_806_297# A3 Y VPB abpmos
X97 a_806_297# A3 Y VPB abpmos
X98 a_27_47# A1 VGND VNB abnmos
X99 a_27_47# A1 VGND VNB abnmos
.ends O32AID4B
