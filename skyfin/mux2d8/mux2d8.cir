* MUX2D8 : abstract conversion of sky130_fd_sc_hd__mux2_8
* 85 abstract devices (width -> parallel min-width fingers)
.subckt MUX2D8 A0 A1 S VGND VPWR X
XMUX2D8B A0 A1 S VGND VGND VPWR VPWR X MUX2D8B
.ends MUX2D8

.subckt MUX2D8B A0 A1 S VGND VNB VPB VPWR X
X0 X a_79_21# VGND VNB abnmos
X1 X a_79_21# VGND VNB abnmos
X2 a_792_47# S VGND VNB abnmos
X3 a_792_47# S VGND VNB abnmos
X4 a_1302_47# A0 a_79_21# VNB abnmos
X5 a_1302_47# A0 a_79_21# VNB abnmos
X6 X a_79_21# VGND VNB abnmos
X7 X a_79_21# VGND VNB abnmos
X8 a_79_21# A1 a_792_47# VNB abnmos
X9 a_79_21# A1 a_792_47# VNB abnmos
X10 a_1302_297# A1 a_79_21# VPB abpmos
X11 a_1302_297# A1 a_79_21# VPB abpmos
X12 a_1302_297# A1 a_79_21# VPB abpmos
X13 a_1302_297# a_1259_199# VPWR VPB abpmos
X14 a_1302_297# a_1259_199# VPWR VPB abpmos
X15 a_1302_297# a_1259_199# VPWR VPB abpmos
X16 X a_79_21# VPWR VPB abpmos
X17 X a_79_21# VPWR VPB abpmos
X18 X a_79_21# VPWR VPB abpmos
X19 a_792_297# S VPWR VPB abpmos
X20 a_792_297# S VPWR VPB abpmos
X21 a_792_297# S VPWR VPB abpmos
X22 a_792_297# A0 a_79_21# VPB abpmos
X23 a_792_297# A0 a_79_21# VPB abpmos
X24 a_792_297# A0 a_79_21# VPB abpmos
X25 a_792_47# A1 a_79_21# VNB abnmos
X26 a_792_47# A1 a_79_21# VNB abnmos
X27 X a_79_21# VPWR VPB abpmos
X28 X a_79_21# VPWR VPB abpmos
X29 X a_79_21# VPWR VPB abpmos
X30 X a_79_21# VGND VNB abnmos
X31 X a_79_21# VGND VNB abnmos
X32 a_792_47# S VGND VNB abnmos
X33 a_792_47# S VGND VNB abnmos
X34 X a_79_21# VPWR VPB abpmos
X35 X a_79_21# VPWR VPB abpmos
X36 X a_79_21# VPWR VPB abpmos
X37 a_1259_199# S VPWR VPB abpmos
X38 a_1259_199# S VPWR VPB abpmos
X39 a_1259_199# S VPWR VPB abpmos
X40 X a_79_21# VGND VNB abnmos
X41 X a_79_21# VGND VNB abnmos
X42 a_1259_199# S VGND VNB abnmos
X43 a_1259_199# S VGND VNB abnmos
X44 X a_79_21# VGND VNB abnmos
X45 X a_79_21# VGND VNB abnmos
X46 a_79_21# A0 a_1302_47# VNB abnmos
X47 a_79_21# A0 a_1302_47# VNB abnmos
X48 a_792_297# S VPWR VPB abpmos
X49 a_792_297# S VPWR VPB abpmos
X50 a_792_297# S VPWR VPB abpmos
X51 X a_79_21# VGND VNB abnmos
X52 X a_79_21# VGND VNB abnmos
X53 X a_79_21# VPWR VPB abpmos
X54 X a_79_21# VPWR VPB abpmos
X55 X a_79_21# VPWR VPB abpmos
X56 X a_79_21# VGND VNB abnmos
X57 X a_79_21# VGND VNB abnmos
X58 a_1302_47# a_1259_199# VGND VNB abnmos
X59 a_1302_47# a_1259_199# VGND VNB abnmos
X60 X a_79_21# VPWR VPB abpmos
X61 X a_79_21# VPWR VPB abpmos
X62 X a_79_21# VPWR VPB abpmos
X63 a_1302_297# a_1259_199# VPWR VPB abpmos
X64 a_1302_297# a_1259_199# VPWR VPB abpmos
X65 a_1302_297# a_1259_199# VPWR VPB abpmos
X66 a_1302_47# a_1259_199# VGND VNB abnmos
X67 a_1302_47# a_1259_199# VGND VNB abnmos
X68 X a_79_21# VPWR VPB abpmos
X69 X a_79_21# VPWR VPB abpmos
X70 X a_79_21# VPWR VPB abpmos
X71 a_79_21# A0 a_792_297# VPB abpmos
X72 a_79_21# A0 a_792_297# VPB abpmos
X73 a_79_21# A0 a_792_297# VPB abpmos
X74 X a_79_21# VPWR VPB abpmos
X75 X a_79_21# VPWR VPB abpmos
X76 X a_79_21# VPWR VPB abpmos
X77 X a_79_21# VGND VNB abnmos
X78 X a_79_21# VGND VNB abnmos
X79 X a_79_21# VPWR VPB abpmos
X80 X a_79_21# VPWR VPB abpmos
X81 X a_79_21# VPWR VPB abpmos
X82 a_79_21# A1 a_1302_297# VPB abpmos
X83 a_79_21# A1 a_1302_297# VPB abpmos
X84 a_79_21# A1 a_1302_297# VPB abpmos
.ends MUX2D8B
