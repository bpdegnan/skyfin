* auto-generated runcell for MUX2D8
.lib "$SPICE_LIB/sky130.lib.spice" tt
.include "$SPICE_DEVICES/devices.cir"
.include "mux2d8.cir"

.param pvdd=1.8V
VVPWR VDD 0 {pvdd}
V_GND VGND 0 0

V_A0 A0 0 PWL( 0ns 0 10ns 0 10.1ns {pvdd} 20ns {pvdd} 20.1ns 0 30ns 0 30.1ns {pvdd} 40ns {pvdd} 40.1ns 0 50ns 0 50.1ns {pvdd} 60ns {pvdd} 60.1ns 0 70ns 0 70.1ns {pvdd} 80ns {pvdd} )
V_A1 A1 0 PWL( 0ns 0 20ns 0 20.1ns {pvdd} 40ns {pvdd} 40.1ns 0 60ns 0 60.1ns {pvdd} 80ns {pvdd} )
V_S S 0 PWL( 0ns 0 40ns 0 40.1ns {pvdd} 80ns {pvdd} )

X1 A0 A1 S VGND VDD X MUX2D8
CL_X X VGND 0.1f

.control
tran 0.05n 80n
wrdata result.raw v(A0) v(A1) v(S) v(X)
.endc
.end
