* LPFLOW_LSBUF_LH_HL_ISOWELL_TAPD1 : abstract conversion of sky130_fd_sc_hd__lpflow_lsbuf_lh_hl_isowell_tap_1
* 32 abstract devices (width -> parallel min-width fingers) ; secondary power ['VPWRIN'] collapsed onto VPWR
.subckt LPFLOW_LSBUF_LH_HL_ISOWELL_TAPD1 A VGND VPWR X
XLPFLOW_LSBUF_LH_HL_ISOWELL_TAPD1B A VGND VPWR VPWR VPWR X LPFLOW_LSBUF_LH_HL_ISOWELL_TAPD1B
.ends LPFLOW_LSBUF_LH_HL_ISOWELL_TAPD1

.subckt LPFLOW_LSBUF_LH_HL_ISOWELL_TAPD1B A VGND VPB VPWRIN VPWR X
X0 X a_1028_32# VPWR VPB abpmos
X1 X a_1028_32# VPWR VPB abpmos
X2 a_714_58# A VGND VGND abnmos
X3 a_714_58# A VGND VGND abnmos
X4 a_714_58# a_620_911# VPWR VPB abpmos
X5 a_714_58# a_620_911# VPWR VPB abpmos
X6 a_620_911# a_505_297# VGND VGND abnmos
X7 a_620_911# a_505_297# VGND VGND abnmos
X8 a_620_911# a_505_297# VGND VGND abnmos
X9 a_620_911# a_505_297# VGND VGND abnmos
X10 VPWRIN A a_505_297# VPWRIN abpmos
X11 VPWRIN A a_505_297# VPWRIN abpmos
X12 VPWRIN A a_505_297# VPWRIN abpmos
X13 a_1028_32# a_620_911# VPWR VPB abpmos
X14 a_1028_32# a_620_911# VPWR VPB abpmos
X15 a_620_911# a_505_297# VGND VGND abnmos
X16 a_620_911# a_505_297# VGND VGND abnmos
X17 a_620_911# a_505_297# VGND VGND abnmos
X18 a_620_911# a_505_297# VGND VGND abnmos
X19 a_714_58# A VGND VGND abnmos
X20 a_714_58# A VGND VGND abnmos
X21 a_714_58# A VGND VGND abnmos
X22 a_714_58# A VGND VGND abnmos
X23 a_1028_32# a_620_911# VGND VGND abnmos
X24 a_1028_32# a_620_911# VGND VGND abnmos
X25 a_620_911# a_714_58# VPWR VPB abpmos
X26 a_620_911# a_714_58# VPWR VPB abpmos
X27 X a_1028_32# VGND VGND abnmos
X28 X a_1028_32# VGND VGND abnmos
X29 a_505_297# A VGND VGND abnmos
X30 a_714_58# A VGND VGND abnmos
X31 a_714_58# A VGND VGND abnmos
.ends LPFLOW_LSBUF_LH_HL_ISOWELL_TAPD1B
