* auto-generated runcell for LPFLOW_LSBUF_LH_HL_ISOWELL_TAPD1
.lib "$SPICE_LIB/sky130.lib.spice" tt
.include "$SPICE_DEVICES/devices.cir"
.include "lpflow_lsbuf_lh_hl_isowell_tapd1.cir"

.param pvdd=1.8V
VVPWR VDD 0 {pvdd}
V_GND VGND 0 0

V_A A 0 PWL( 0ns 0 10ns 0 10.1ns {pvdd} 20ns {pvdd} )

X1 A VGND VDD X LPFLOW_LSBUF_LH_HL_ISOWELL_TAPD1
CL_X X VGND 0.1f

.control
tran 0.05n 20n
wrdata result.raw v(A) v(X)
.endc
.end
