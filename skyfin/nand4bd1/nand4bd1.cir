* NAND4BD1 : abstract conversion of sky130_fd_sc_hd__nand4b_1
* 22 abstract devices (width -> parallel min-width fingers)
.subckt NAND4BD1 A_N B C D VGND VPWR Y
XNAND4BD1B A_N B C D VGND VGND VPWR VPWR Y NAND4BD1B
.ends NAND4BD1

.subckt NAND4BD1B A_N B C D VGND VNB VPB VPWR Y
X0 Y a_41_93# VPWR VPB abpmos
X1 Y a_41_93# VPWR VPB abpmos
X2 Y a_41_93# VPWR VPB abpmos
X3 a_232_47# C a_316_47# VNB abnmos
X4 a_232_47# C a_316_47# VNB abnmos
X5 a_423_47# a_41_93# Y VNB abnmos
X6 a_423_47# a_41_93# Y VNB abnmos
X7 a_41_93# A_N VPWR VPB abpmos
X8 Y D VPWR VPB abpmos
X9 Y D VPWR VPB abpmos
X10 Y D VPWR VPB abpmos
X11 a_316_47# B a_423_47# VNB abnmos
X12 a_316_47# B a_423_47# VNB abnmos
X13 a_41_93# A_N VGND VNB abnmos
X14 Y B VPWR VPB abpmos
X15 Y B VPWR VPB abpmos
X16 Y B VPWR VPB abpmos
X17 Y C VPWR VPB abpmos
X18 Y C VPWR VPB abpmos
X19 Y C VPWR VPB abpmos
X20 a_232_47# D VGND VNB abnmos
X21 a_232_47# D VGND VNB abnmos
.ends NAND4BD1B
