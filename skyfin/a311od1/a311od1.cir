* A311OD1 : abstract conversion of sky130_fd_sc_hd__a311o_1
* 30 abstract devices (width -> parallel min-width fingers)
.subckt A311OD1 A1 A2 A3 B1 C1 VGND VPWR X
XA311OD1B A1 A2 A3 B1 C1 VGND VGND VPWR VPWR X A311OD1B
.ends A311OD1

.subckt A311OD1B A1 A2 A3 B1 C1 VGND VNB VPB VPWR X
X0 a_201_297# A1 VPWR VPB abpmos
X1 a_201_297# A1 VPWR VPB abpmos
X2 a_201_297# A1 VPWR VPB abpmos
X3 a_208_47# A3 VGND VNB abnmos
X4 a_208_47# A3 VGND VNB abnmos
X5 a_75_199# B1 VGND VNB abnmos
X6 a_75_199# B1 VGND VNB abnmos
X7 a_544_297# C1 a_75_199# VPB abpmos
X8 a_544_297# C1 a_75_199# VPB abpmos
X9 a_544_297# C1 a_75_199# VPB abpmos
X10 a_201_297# A2 VPWR VPB abpmos
X11 a_201_297# A2 VPWR VPB abpmos
X12 a_201_297# A2 VPWR VPB abpmos
X13 X a_75_199# VPWR VPB abpmos
X14 X a_75_199# VPWR VPB abpmos
X15 X a_75_199# VPWR VPB abpmos
X16 a_208_47# A2 a_315_47# VNB abnmos
X17 a_208_47# A2 a_315_47# VNB abnmos
X18 a_201_297# A3 VPWR VPB abpmos
X19 a_201_297# A3 VPWR VPB abpmos
X20 a_201_297# A3 VPWR VPB abpmos
X21 a_75_199# C1 VGND VNB abnmos
X22 a_75_199# C1 VGND VNB abnmos
X23 X a_75_199# VGND VNB abnmos
X24 X a_75_199# VGND VNB abnmos
X25 a_315_47# A1 a_75_199# VNB abnmos
X26 a_315_47# A1 a_75_199# VNB abnmos
X27 a_201_297# B1 a_544_297# VPB abpmos
X28 a_201_297# B1 a_544_297# VPB abpmos
X29 a_201_297# B1 a_544_297# VPB abpmos
.ends A311OD1B
