* OR3BD4 : abstract conversion of sky130_fd_sc_hd__or3b_4
* 37 abstract devices (width -> parallel min-width fingers)
.subckt OR3BD4 A B C_N VGND VPWR X
XOR3BD4B A B C_N VGND VGND VPWR VPWR X OR3BD4B
.ends OR3BD4

.subckt OR3BD4B A B C_N VGND VNB VPB VPWR X
X0 X a_176_21# VGND VNB abnmos
X1 X a_176_21# VGND VNB abnmos
X2 X a_176_21# VGND VNB abnmos
X3 X a_176_21# VGND VNB abnmos
X4 a_542_297# B a_626_297# VPB abpmos
X5 a_542_297# B a_626_297# VPB abpmos
X6 a_542_297# B a_626_297# VPB abpmos
X7 X a_176_21# VGND VNB abnmos
X8 X a_176_21# VGND VNB abnmos
X9 a_626_297# a_27_47# a_176_21# VPB abpmos
X10 a_626_297# a_27_47# a_176_21# VPB abpmos
X11 a_626_297# a_27_47# a_176_21# VPB abpmos
X12 a_27_47# C_N VPWR VPB abpmos
X13 X a_176_21# VGND VNB abnmos
X14 X a_176_21# VGND VNB abnmos
X15 a_176_21# A VGND VNB abnmos
X16 a_176_21# A VGND VNB abnmos
X17 X a_176_21# VPWR VPB abpmos
X18 X a_176_21# VPWR VPB abpmos
X19 X a_176_21# VPWR VPB abpmos
X20 a_27_47# C_N VGND VNB abnmos
X21 X a_176_21# VPWR VPB abpmos
X22 X a_176_21# VPWR VPB abpmos
X23 X a_176_21# VPWR VPB abpmos
X24 a_176_21# a_27_47# VGND VNB abnmos
X25 a_176_21# a_27_47# VGND VNB abnmos
X26 X a_176_21# VPWR VPB abpmos
X27 X a_176_21# VPWR VPB abpmos
X28 X a_176_21# VPWR VPB abpmos
X29 a_542_297# A VPWR VPB abpmos
X30 a_542_297# A VPWR VPB abpmos
X31 a_542_297# A VPWR VPB abpmos
X32 a_176_21# B VGND VNB abnmos
X33 a_176_21# B VGND VNB abnmos
X34 X a_176_21# VPWR VPB abpmos
X35 X a_176_21# VPWR VPB abpmos
X36 X a_176_21# VPWR VPB abpmos
.ends OR3BD4B
